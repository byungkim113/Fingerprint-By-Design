* NGSPICE file created from ldo_blk.ext - technology: sky130A

.subckt ldo_blk VIN VOUT VSS
X0 VIN a_48189_20638# VOUT VIN sky130_fd_pr__pfet_g5v0d10v5 ad=1.45 pd=10.29 as=1.45 ps=10.29 w=10 l=0.5
X1 VSS VSS a_4610_3570# sky130_fd_pr__pnp_05v5_W3p40L3p40
**devattr s=462400,2720
X2 VSS a_43557_20638# a_55959_20601# VSS sky130_fd_pr__nfet_g5v0d10v5 ad=2.32 pd=16.58 as=2.32 ps=16.58 w=8 l=2
X3 VSS a_19151_20601# a_26813_20601# VSS sky130_fd_pr__nfet_g5v0d10v5 ad=4.64 pd=32.58 as=4.64 ps=32.58 w=16 l=32
X4 a_48189_20638# VOUT sky130_fd_pr__cap_mim_m3_1 l=22 w=22
X5 VIN a_48189_20638# VOUT VIN sky130_fd_pr__pfet_g5v0d10v5 ad=1.45 pd=10.29 as=1.45 ps=10.29 w=10 l=0.5
X6 a_22135_35889# VSS VSS sky130_fd_pr__res_xhigh_po_1p41 l=35.25
X7 VSS VSS a_4610_3570# sky130_fd_pr__pnp_05v5_W3p40L3p40
**devattr s=462400,2720
X8 a_59341_20513# VSS sky130_fd_pr__cap_mim_m3_1 l=28.6 w=28.6
X9 VSS VOUT VSS VSS sky130_fd_pr__nfet_01v8 ad=5.8 pd=40.58 as=302.16 ps=1.9294k w=20 l=20
X10 a_92821_20497# a_94213_20497# VSS sky130_fd_pr__res_xhigh_po_1p41 l=35.25
X11 VIN a_48189_20638# VOUT VIN sky130_fd_pr__pfet_g5v0d10v5 ad=1.45 pd=10.29 as=1.45 ps=10.29 w=10 l=0.5
X12 a_42955_5395# a_4610_3570# VSS sky130_fd_pr__res_xhigh_po_1p41 l=8
X13 a_87253_20497# a_88645_20497# VSS sky130_fd_pr__res_xhigh_po_1p41 l=35.25
X14 VSS VOUT VSS VSS sky130_fd_pr__nfet_01v8 ad=5.8 pd=40.58 as=0 ps=0 w=20 l=20
X15 VSS VOUT VSS VSS sky130_fd_pr__nfet_01v8 ad=5.8 pd=40.58 as=0 ps=0 w=20 l=20
X16 VIN a_26813_20601# a_70323_3536# VIN sky130_fd_pr__pfet_g5v0d10v5 ad=4.64 pd=32.58 as=4.64 ps=32.58 w=16 l=32
X17 a_34533_20513# a_44347_3395# VSS sky130_fd_pr__res_xhigh_po_1p41 l=39
X18 VIN a_73383_20638# a_48189_20638# VIN sky130_fd_pr__pfet_g5v0d10v5 ad=1.45 pd=10.29 as=2.9 ps=20.58 w=10 l=0.5
X19 VSS a_11489_20601# a_11489_20601# VSS sky130_fd_pr__nfet_g5v0d10v5 ad=4.64 pd=32.58 as=4.64 ps=32.58 w=16 l=32
X20 VIN VSS a_66605_20638# VIN sky130_fd_pr__pfet_g5v0d10v5 ad=0.1218 pd=1.42 as=0.1218 ps=1.42 w=0.42 l=20
X21 VIN a_46473_20638# a_46473_20638# VIN sky130_fd_pr__pfet_g5v0d10v5 ad=5.8 pd=40.58 as=5.8 ps=40.58 w=20 l=2
X22 a_26813_20601# a_19151_20601# sky130_fd_pr__cap_mim_m3_1 l=22 w=22
X23 VSS VSS a_4610_3570# sky130_fd_pr__pnp_05v5_W3p40L3p40
**devattr s=462400,2720
X24 VSS VSS a_4610_3570# sky130_fd_pr__pnp_05v5_W3p40L3p40
**devattr s=462400,2720
X25 a_48189_20638# a_73383_20638# VIN VIN sky130_fd_pr__pfet_g5v0d10v5 ad=1.45 pd=10.29 as=1.45 ps=10.29 w=10 l=0.5
X26 VSS VOUT VSS VSS sky130_fd_pr__nfet_01v8 ad=5.8 pd=40.58 as=0 ps=0 w=20 l=20
X27 VOUT a_48189_20638# VIN VIN sky130_fd_pr__pfet_g5v0d10v5 ad=1.45 pd=10.29 as=1.45 ps=10.29 w=10 l=0.5
X28 a_95605_20497# a_59341_20513# VSS sky130_fd_pr__res_xhigh_po_1p41 l=35.25
X29 VSS VOUT VSS VSS sky130_fd_pr__nfet_01v8 ad=5.8 pd=40.58 as=0 ps=0 w=20 l=20
X30 VIN a_48189_20638# VOUT VIN sky130_fd_pr__pfet_g5v0d10v5 ad=1.45 pd=10.29 as=1.45 ps=10.29 w=10 l=0.5
X31 VIN a_26813_20601# a_26813_20601# VIN sky130_fd_pr__pfet_g5v0d10v5 ad=4.64 pd=32.58 as=4.64 ps=32.58 w=16 l=32
X32 a_59341_20513# VSS sky130_fd_pr__cap_mim_m3_1 l=28.6 w=28.6
X33 VSS VSS a_4610_3570# sky130_fd_pr__pnp_05v5_W3p40L3p40
**devattr s=462400,2720
X34 VSS VSS a_38850_3570# sky130_fd_pr__pnp_05v5_W3p40L3p40
**devattr s=462400,2720
X35 a_94213_20497# a_95605_20497# VSS sky130_fd_pr__res_xhigh_po_1p41 l=35.25
X36 VSS VSS a_38850_3570# sky130_fd_pr__pnp_05v5_W3p40L3p40
**devattr s=462400,2720
X37 VSS VOUT VSS VSS sky130_fd_pr__nfet_01v8 ad=5.8 pd=40.58 as=0 ps=0 w=20 l=20
X38 VSS VOUT VSS VSS sky130_fd_pr__nfet_01v8 ad=5.8 pd=40.58 as=0 ps=0 w=20 l=20
X39 VSS VSS a_330_3570# sky130_fd_pr__pnp_05v5_W3p40L3p40
**devattr s=462400,2720
X40 VIN a_46473_20638# a_48189_20638# VIN sky130_fd_pr__pfet_g5v0d10v5 ad=5.8 pd=40.58 as=5.8 ps=40.58 w=20 l=2
X41 VSS VSS a_330_3570# sky130_fd_pr__pnp_05v5_W3p40L3p40
**devattr s=462400,2720
X42 VSS VOUT VSS VSS sky130_fd_pr__nfet_01v8 ad=5.8 pd=40.58 as=0 ps=0 w=20 l=20
X43 a_59341_20513# VSS sky130_fd_pr__cap_mim_m3_1 l=28.6 w=28.6
X44 VSS VSS a_4610_3570# sky130_fd_pr__pnp_05v5_W3p40L3p40
**devattr s=462400,2720
X45 a_55959_20601# a_20743_35889# a_46473_20638# VSS sky130_fd_pr__nfet_g5v0d10v5 ad=5.8 pd=40.58 as=5.8 ps=40.58 w=20 l=2
X46 VSS VSS a_4610_3570# sky130_fd_pr__pnp_05v5_W3p40L3p40
**devattr s=462400,2720
X47 VSS a_43557_20638# a_43557_20638# VSS sky130_fd_pr__nfet_g5v0d10v5 ad=1.16 pd=8.58 as=1.16 ps=8.58 w=4 l=2
X48 VOUT a_48189_20638# VIN VIN sky130_fd_pr__pfet_g5v0d10v5 ad=1.45 pd=10.29 as=1.45 ps=10.29 w=10 l=0.5
X49 VIN a_26813_20601# a_43557_20638# VIN sky130_fd_pr__pfet_g5v0d10v5 ad=1.16 pd=8.58 as=1.16 ps=8.58 w=4 l=8
X50 VSS VOUT VSS VSS sky130_fd_pr__nfet_01v8 ad=5.8 pd=40.58 as=0 ps=0 w=20 l=20
X51 VOUT a_48189_20638# VIN VIN sky130_fd_pr__pfet_g5v0d10v5 ad=1.45 pd=10.29 as=1.45 ps=10.29 w=10 l=0.5
X52 VIN a_26813_20601# a_42955_5395# VIN sky130_fd_pr__pfet_g5v0d10v5 ad=4.64 pd=32.58 as=4.64 ps=32.58 w=16 l=32
X53 a_70323_3536# a_42955_5395# a_19151_20601# VIN sky130_fd_pr__pfet_g5v0d10v5 ad=2.32 pd=16.58 as=2.32 ps=16.58 w=8 l=16
X54 VIN a_48189_20638# VOUT VIN sky130_fd_pr__pfet_g5v0d10v5 ad=1.45 pd=10.29 as=1.45 ps=10.29 w=10 l=0.5
X55 VSS VOUT VSS VSS sky130_fd_pr__nfet_01v8 ad=5.8 pd=40.58 as=0 ps=0 w=20 l=20
X56 VSS VSS a_4610_3570# sky130_fd_pr__pnp_05v5_W3p40L3p40
**devattr s=462400,2720
X57 VIN a_48189_20638# VOUT VIN sky130_fd_pr__pfet_g5v0d10v5 ad=1.45 pd=10.29 as=1.45 ps=10.29 w=10 l=0.5
X58 VOUT a_48189_20638# VIN VIN sky130_fd_pr__pfet_g5v0d10v5 ad=1.45 pd=10.29 as=1.45 ps=10.29 w=10 l=0.5
X59 VIN a_48189_20638# VOUT VIN sky130_fd_pr__pfet_g5v0d10v5 ad=1.45 pd=10.29 as=1.45 ps=10.29 w=10 l=0.5
X60 VSS VOUT VSS VSS sky130_fd_pr__nfet_01v8 ad=5.8 pd=40.58 as=0 ps=0 w=20 l=20
X61 VSS VSS a_4610_3570# sky130_fd_pr__pnp_05v5_W3p40L3p40
**devattr s=462400,2720
X62 VSS a_34533_20513# a_66605_20638# VSS sky130_fd_pr__nfet_g5v0d10v5 ad=0.58 pd=4.58 as=0.58 ps=4.58 w=2 l=1
X63 VSS VSS a_4610_3570# sky130_fd_pr__pnp_05v5_W3p40L3p40
**devattr s=462400,2720
X64 VIN a_48189_20638# VOUT VIN sky130_fd_pr__pfet_g5v0d10v5 ad=1.45 pd=10.29 as=1.45 ps=10.29 w=10 l=0.5
X65 a_73383_20638# VSS sky130_fd_pr__cap_mim_m3_1 l=10 w=10
X66 VOUT a_48189_20638# VIN VIN sky130_fd_pr__pfet_g5v0d10v5 ad=2.9 pd=20.58 as=1.45 ps=10.29 w=10 l=0.5
X67 VSS a_199_20638# a_26813_20601# VSS sky130_fd_pr__nfet_g5v0d10v5 ad=0.145 pd=1.58 as=0.145 ps=1.58 w=0.5 l=4
X68 VIN a_73383_20638# a_48189_20638# VIN sky130_fd_pr__pfet_g5v0d10v5 ad=1.45 pd=10.29 as=1.45 ps=10.29 w=10 l=0.5
X69 VIN a_48189_20638# VOUT VIN sky130_fd_pr__pfet_g5v0d10v5 ad=1.45 pd=10.29 as=1.45 ps=10.29 w=10 l=0.5
X70 VSS a_11489_20601# a_19151_20601# VSS sky130_fd_pr__nfet_g5v0d10v5 ad=4.64 pd=32.58 as=4.64 ps=32.58 w=16 l=32
X71 a_48189_20638# a_73383_20638# VIN VIN sky130_fd_pr__pfet_g5v0d10v5 ad=2.9 pd=20.58 as=1.45 ps=10.29 w=10 l=0.5
X72 VSS VOUT VSS VSS sky130_fd_pr__nfet_01v8 ad=5.8 pd=40.58 as=0 ps=0 w=20 l=20
X73 VOUT a_20743_35889# VSS sky130_fd_pr__res_xhigh_po_1p41 l=34.1
X74 a_88645_20497# a_90037_20497# VSS sky130_fd_pr__res_xhigh_po_1p41 l=35.25
X75 VOUT a_48189_20638# VIN VIN sky130_fd_pr__pfet_g5v0d10v5 ad=1.45 pd=10.29 as=1.45 ps=10.29 w=10 l=0.5
X76 VOUT a_48189_20638# VIN VIN sky130_fd_pr__pfet_g5v0d10v5 ad=1.45 pd=10.29 as=1.45 ps=10.29 w=10 l=0.5
X77 a_59341_20513# VSS sky130_fd_pr__cap_mim_m3_1 l=28.6 w=28.6
X78 a_34533_20513# a_84469_20497# VSS sky130_fd_pr__res_xhigh_po_1p41 l=35.25
X79 a_70323_3536# a_330_3570# a_11489_20601# VIN sky130_fd_pr__pfet_g5v0d10v5 ad=2.32 pd=16.58 as=2.32 ps=16.58 w=8 l=16
X80 a_84469_20497# a_85861_20497# VSS sky130_fd_pr__res_xhigh_po_1p41 l=35.25
X81 VIN a_66605_20638# a_73383_20638# VIN sky130_fd_pr__pfet_g5v0d10v5 ad=0.58 pd=4.58 as=0.58 ps=4.58 w=2 l=0.5
X82 VSS VSS a_4610_3570# sky130_fd_pr__pnp_05v5_W3p40L3p40
**devattr s=462400,2720
X83 a_59341_20513# VSS sky130_fd_pr__cap_mim_m3_1 l=28.6 w=28.6
X84 VIN a_26813_20601# a_330_3570# VIN sky130_fd_pr__pfet_g5v0d10v5 ad=4.64 pd=32.58 as=4.64 ps=32.58 w=16 l=32
X85 a_55959_20601# a_59341_20513# a_48189_20638# VSS sky130_fd_pr__nfet_g5v0d10v5 ad=5.8 pd=40.58 as=5.8 ps=40.58 w=20 l=2
X86 VIN a_26813_20601# a_34533_20513# VIN sky130_fd_pr__pfet_g5v0d10v5 ad=4.64 pd=32.58 as=4.64 ps=32.58 w=16 l=32
X87 VIN VSS a_199_20638# VIN sky130_fd_pr__pfet_g5v0d10v5 ad=0.1218 pd=1.42 as=0.1218 ps=1.42 w=0.42 l=50
X88 a_20743_35889# a_22135_35889# VSS sky130_fd_pr__res_xhigh_po_1p41 l=35.25
X89 VSS VSS a_4610_3570# sky130_fd_pr__pnp_05v5_W3p40L3p40
**devattr s=462400,2720
X90 VSS VSS a_4610_3570# sky130_fd_pr__pnp_05v5_W3p40L3p40
**devattr s=462400,2720
X91 VIN a_48189_20638# VOUT VIN sky130_fd_pr__pfet_g5v0d10v5 ad=1.45 pd=10.29 as=2.9 ps=20.58 w=10 l=0.5
X92 a_85861_20497# a_87253_20497# VSS sky130_fd_pr__res_xhigh_po_1p41 l=35.25
X93 a_66605_20638# VIN sky130_fd_pr__cap_mim_m3_1 l=10 w=10
X94 a_44347_3395# a_38850_3570# VSS sky130_fd_pr__res_xhigh_po_1p41 l=39
X95 VSS VSS a_4610_3570# sky130_fd_pr__pnp_05v5_W3p40L3p40
**devattr s=462400,2720
X96 VOUT a_48189_20638# VIN VIN sky130_fd_pr__pfet_g5v0d10v5 ad=1.45 pd=10.29 as=1.45 ps=10.29 w=10 l=0.5
X97 a_90037_20497# a_91429_20497# VSS sky130_fd_pr__res_xhigh_po_1p41 l=35.25
X98 VSS VOUT VSS VSS sky130_fd_pr__nfet_01v8 ad=5.8 pd=40.58 as=0 ps=0 w=20 l=20
X99 a_91429_20497# a_92821_20497# VSS sky130_fd_pr__res_xhigh_po_1p41 l=35.25
X100 VSS a_66605_20638# a_73383_20638# VSS sky130_fd_pr__nfet_g5v0d10v5 ad=0.29 pd=2.58 as=0.29 ps=2.58 w=1 l=0.5
X101 VSS a_34533_20513# a_199_20638# VSS sky130_fd_pr__nfet_g5v0d10v5 ad=1.16 pd=8.58 as=1.16 ps=8.58 w=4 l=0.5
X102 VSS VSS a_4610_3570# sky130_fd_pr__pnp_05v5_W3p40L3p40
**devattr s=462400,2720
X103 VSS VOUT VSS VSS sky130_fd_pr__nfet_01v8 ad=5.8 pd=40.58 as=0 ps=0 w=20 l=20
X104 a_59341_20513# VSS sky130_fd_pr__cap_mim_m3_1 l=28.6 w=28.6
X105 VOUT a_48189_20638# VIN VIN sky130_fd_pr__pfet_g5v0d10v5 ad=1.45 pd=10.29 as=1.45 ps=10.29 w=10 l=0.5
X106 VSS VOUT VSS VSS sky130_fd_pr__nfet_01v8 ad=5.8 pd=40.58 as=0 ps=0 w=20 l=20
X107 VSS VSS a_4610_3570# sky130_fd_pr__pnp_05v5_W3p40L3p40
**devattr s=462400,2720
X108 VOUT a_48189_20638# VIN VIN sky130_fd_pr__pfet_g5v0d10v5 ad=1.45 pd=10.29 as=1.45 ps=10.29 w=10 l=0.5
C0 a_20743_35889# VOUT 3.89751f
C1 a_84469_20497# a_92821_20497# 0
C2 a_85861_20497# a_91429_20497# 0
C3 a_87253_20497# a_90037_20497# 0.00356f
C4 a_66605_20638# a_94213_20497# 0.34594f
C5 a_59341_20513# a_95605_20497# 2.09508f
C6 a_34533_20513# a_38850_3570# 0
C7 a_11489_20601# a_44347_3395# 0.15105f
C8 a_26813_20601# a_42955_5395# 4.80836f
C9 a_11489_20601# a_95605_20497# 0.0791f
C10 a_19151_20601# a_94213_20497# 0.07703f
C11 a_34533_20513# a_92821_20497# 0.19446f
C12 a_84469_20497# a_87253_20497# 0.00356f
C13 a_66605_20638# a_88645_20497# 0.34545f
C14 a_59341_20513# a_90037_20497# 0.06468f
C15 a_11489_20601# a_90037_20497# 0.0753f
C16 a_19151_20601# a_88645_20497# 0.07703f
C17 a_34533_20513# a_87253_20497# 0.19392f
C18 a_59341_20513# a_84469_20497# 0.06867f
C19 a_48189_20638# a_85861_20497# 0.00627f
C20 a_19151_20601# a_66605_20638# 0.07703f
C21 a_26813_20601# a_73383_20638# 1.09438f
C22 a_11489_20601# a_84469_20497# 0.07535f
C23 a_34533_20513# a_59341_20513# 13.4524f
C24 a_43557_20638# a_55959_20601# 0.68297f
C25 a_11489_20601# a_34533_20513# 0.15116f
C26 a_20743_35889# a_73383_20638# 0.09284f
C27 a_46473_20638# a_43557_20638# 0.1594f
C28 a_199_20638# a_26813_20601# 0.17083f
C29 a_94213_20497# VOUT 0.07727f
C30 a_4610_3570# a_44347_3395# 0.03652f
C31 a_20743_35889# a_199_20638# 0.00128f
C32 a_88645_20497# VOUT 0.07727f
C33 a_66605_20638# VOUT 0.08523f
C34 a_19151_20601# VOUT 0.25516f
C35 a_26813_20601# VIN 73.6451f
C36 a_19151_20601# a_42955_5395# 0.878f
C37 a_26813_20601# a_38850_3570# 0.07343f
C38 a_20743_35889# VIN 0.05447f
C39 a_55959_20601# a_95605_20497# 0.79095f
C40 a_73383_20638# a_94213_20497# 0.42384f
C41 a_26813_20601# a_92821_20497# 0.08718f
C42 a_73383_20638# a_88645_20497# 0.42347f
C43 a_55959_20601# a_90037_20497# 0.19411f
C44 a_43557_20638# a_91429_20497# 0.2594f
C45 a_20743_35889# a_92821_20497# 0.08742f
C46 a_55959_20601# a_84469_20497# 0.20602f
C47 a_43557_20638# a_85861_20497# 0.25873f
C48 a_26813_20601# a_87253_20497# 0.09901f
C49 a_73383_20638# a_66605_20638# 29.329f
C50 a_19151_20601# a_73383_20638# 0.08237f
C51 a_26813_20601# a_59341_20513# 0.23759f
C52 a_20743_35889# a_87253_20497# 0.09496f
C53 a_46473_20638# a_84469_20497# 0.00133f
C54 a_43557_20638# a_48189_20638# 0.40283f
C55 a_46473_20638# a_34533_20513# 0.06468f
C56 a_20743_35889# a_59341_20513# 0.44772f
C57 a_199_20638# a_19151_20601# 11.8271f
C58 a_11489_20601# a_26813_20601# 0.26011f
C59 a_330_3570# a_44347_3395# 0.14323f
C60 a_94213_20497# VIN 0.08356f
C61 a_20743_35889# a_11489_20601# 0
C62 a_88645_20497# VIN 0.08356f
C63 a_73383_20638# VOUT 0.08261f
C64 a_66605_20638# VIN 10.2406f
C65 a_91429_20497# a_95605_20497# 0.00155f
C66 a_92821_20497# a_94213_20497# 33.5001f
C67 a_73383_20638# a_42955_5395# 0
C68 a_199_20638# VOUT 0.20533f
C69 a_19151_20601# VIN 2.58152f
C70 a_85861_20497# a_95605_20497# 0
C71 a_87253_20497# a_94213_20497# 0
C72 a_88645_20497# a_92821_20497# 0.00155f
C73 a_90037_20497# a_91429_20497# 32.3118f
C74 a_84469_20497# a_91429_20497# 0
C75 a_85861_20497# a_90037_20497# 0.00155f
C76 a_59341_20513# a_94213_20497# 0.06546f
C77 a_66605_20638# a_92821_20497# 0.34578f
C78 a_87253_20497# a_88645_20497# 31.1236f
C79 a_19151_20601# a_38850_3570# 1.23788f
C80 a_26813_20601# a_4610_3570# 0
C81 a_34533_20513# a_330_3570# 0.07694f
C82 a_11489_20601# a_94213_20497# 0.0753f
C83 a_19151_20601# a_92821_20497# 0.07703f
C84 a_66605_20638# a_87253_20497# 0.34545f
C85 a_59341_20513# a_88645_20497# 0.06468f
C86 a_48189_20638# a_90037_20497# 0.00147f
C87 a_34533_20513# a_91429_20497# 0.19426f
C88 a_84469_20497# a_85861_20497# 29.9354f
C89 a_11489_20601# a_88645_20497# 0.0753f
C90 a_19151_20601# a_87253_20497# 0.07703f
C91 a_48189_20638# a_84469_20497# 4.60454f
C92 a_34533_20513# a_85861_20497# 0.19392f
C93 a_59341_20513# a_66605_20638# 25.7567f
C94 VIN VOUT 30.4133f
C95 a_11489_20601# a_66605_20638# 0.0753f
C96 a_19151_20601# a_59341_20513# 0.07703f
C97 a_34533_20513# a_48189_20638# 0.06468f
C98 a_42955_5395# VIN 8.39397f
C99 a_20743_35889# a_55959_20601# 1.64705f
C100 a_46473_20638# a_26813_20601# 0.30472f
C101 a_11489_20601# a_19151_20601# 25.85f
C102 a_92821_20497# VOUT 0.07727f
C103 a_38850_3570# a_42955_5395# 0.1997f
C104 a_20743_35889# a_46473_20638# 9.56056f
C105 a_87253_20497# VOUT 0.07727f
C106 a_59341_20513# VOUT 1.13531f
C107 a_73383_20638# VIN 3.56534f
C108 a_199_20638# VIN 0.38298f
C109 a_11489_20601# VOUT 0.1941f
C110 a_26813_20601# a_70323_3536# 2.99072f
C111 a_73383_20638# a_92821_20497# 0.42347f
C112 a_55959_20601# a_94213_20497# 0.19445f
C113 a_43557_20638# a_95605_20497# 17.4236f
C114 a_11489_20601# a_42955_5395# 3.26869f
C115 a_19151_20601# a_4610_3570# 0.00763f
C116 a_26813_20601# a_330_3570# 2.07457f
C117 a_73383_20638# a_87253_20497# 0.42347f
C118 a_55959_20601# a_88645_20497# 0.19409f
C119 a_26813_20601# a_91429_20497# 0.0875f
C120 a_43557_20638# a_90037_20497# 0.25916f
C121 a_20743_35889# a_91429_20497# 0.08742f
C122 a_55959_20601# a_66605_20638# 0
C123 a_46473_20638# a_88645_20497# 0
C124 a_43557_20638# a_84469_20497# 0.27469f
C125 a_26813_20601# a_85861_20497# 0.10362f
C126 a_199_20638# a_87253_20497# 0
C127 a_59341_20513# a_73383_20638# 0.48325f
C128 a_11489_20601# a_73383_20638# 0.08064f
C129 a_20743_35889# a_85861_20497# 0.09618f
C130 a_26813_20601# a_48189_20638# 15.785f
C131 a_34533_20513# a_43557_20638# 12.7365f
C132 a_38850_3570# VIN 0.27716f
C133 a_46473_20638# a_19151_20601# 0.71001f
C134 a_22135_35889# a_34533_20513# 0
C135 a_11489_20601# a_199_20638# 0.14275f
C136 a_20743_35889# a_48189_20638# 10.6326f
C137 a_4610_3570# a_42955_5395# 7.017f
C138 a_92821_20497# VIN 0.08356f
C139 a_87253_20497# VIN 0.08356f
C140 a_55959_20601# VOUT 0.24765f
C141 a_59341_20513# VIN 0.13802f
C142 a_90037_20497# a_95605_20497# 0
C143 a_91429_20497# a_94213_20497# 0.00356f
C144 a_85861_20497# a_94213_20497# 0
C145 a_87253_20497# a_92821_20497# 0
C146 a_88645_20497# a_91429_20497# 0.00356f
C147 a_19151_20601# a_70323_3536# 1.24706f
C148 a_34533_20513# a_44347_3395# 0.10124f
C149 a_46473_20638# VOUT 0.20797f
C150 a_11489_20601# VIN 4.04712f
C151 a_84469_20497# a_90037_20497# 0
C152 a_85861_20497# a_88645_20497# 0.00356f
C153 a_66605_20638# a_91429_20497# 0.34545f
C154 a_34533_20513# a_95605_20497# 2.39276f
C155 a_59341_20513# a_92821_20497# 0.06518f
C156 a_11489_20601# a_38850_3570# 0.19846f
C157 a_19151_20601# a_330_3570# 0.00102f
C158 a_11489_20601# a_92821_20497# 0.0753f
C159 a_19151_20601# a_91429_20497# 0.07703f
C160 a_66605_20638# a_85861_20497# 0.34545f
C161 a_59341_20513# a_87253_20497# 0.06468f
C162 a_48189_20638# a_88645_20497# 0.00224f
C163 a_34533_20513# a_90037_20497# 0.19416f
C164 a_11489_20601# a_87253_20497# 0.0753f
C165 a_55959_20601# a_73383_20638# 0
C166 a_19151_20601# a_85861_20497# 0.07717f
C167 a_34533_20513# a_84469_20497# 0.26298f
C168 a_48189_20638# a_66605_20638# 0.1781f
C169 a_11489_20601# a_59341_20513# 0.0753f
C170 a_19151_20601# a_48189_20638# 0.08686f
C171 a_26813_20601# a_43557_20638# 0.54797f
C172 a_4610_3570# VIN 1.61225f
C173 a_42955_5395# a_70323_3536# 0.87649f
C174 a_46473_20638# a_199_20638# 13.6176f
C175 a_20743_35889# a_43557_20638# 0.23824f
C176 a_91429_20497# VOUT 0.07727f
C177 a_4610_3570# a_38850_3570# 0.14325f
C178 a_330_3570# a_42955_5395# 23.0454f
C179 a_20743_35889# a_22135_35889# 8.68882f
C180 a_85861_20497# VOUT 0.07727f
C181 a_55959_20601# VIN 0.20683f
C182 a_48189_20638# VOUT 51.0074f
C183 a_46473_20638# VIN 7.38724f
C184 a_26813_20601# a_44347_3395# 11.5203f
C185 a_26813_20601# a_95605_20497# 0.09099f
C186 a_73383_20638# a_91429_20497# 0.42347f
C187 a_55959_20601# a_92821_20497# 0.19422f
C188 a_43557_20638# a_94213_20497# 0.26131f
C189 a_11489_20601# a_4610_3570# 5.92097f
C190 a_20743_35889# a_95605_20497# 0.08742f
C191 a_73383_20638# a_85861_20497# 0.42347f
C192 a_55959_20601# a_87253_20497# 0.19405f
C193 a_26813_20601# a_90037_20497# 0.09517f
C194 a_43557_20638# a_88645_20497# 0.25895f
C195 a_20743_35889# a_90037_20497# 0.08742f
C196 a_46473_20638# a_87253_20497# 0
C197 a_26813_20601# a_84469_20497# 14.7512f
C198 a_43557_20638# a_66605_20638# 0.00292f
C199 a_199_20638# a_85861_20497# 0
C200 a_48189_20638# a_73383_20638# 1.79313f
C201 a_55959_20601# a_59341_20513# 1.94615f
C202 a_70323_3536# VIN 3.45988f
C203 a_20743_35889# a_84469_20497# 0.09795f
C204 a_199_20638# a_48189_20638# 0.00272f
C205 a_22135_35889# a_66605_20638# 0
C206 a_19151_20601# a_43557_20638# 0.10391f
C207 a_26813_20601# a_34533_20513# 19.6264f
C208 a_330_3570# VIN 15.8637f
C209 a_20743_35889# a_34533_20513# 0.1521f
C210 a_46473_20638# a_11489_20601# 0.07649f
C211 a_91429_20497# VIN 0.08356f
C212 a_330_3570# a_38850_3570# 0.21951f
C213 a_85861_20497# VIN 0.08356f
C214 a_94213_20497# a_95605_20497# 34.0942f
C215 a_43557_20638# VOUT 0.24813f
C216 a_48189_20638# VIN 20.579f
C217 a_88645_20497# a_95605_20497# 0
C218 a_90037_20497# a_94213_20497# 0.00155f
C219 a_91429_20497# a_92821_20497# 32.906f
C220 a_66605_20638# a_44347_3395# 0
C221 a_22135_35889# VOUT 0.26625f
C222 a_84469_20497# a_94213_20497# 0
C223 a_85861_20497# a_92821_20497# 0
C224 a_87253_20497# a_91429_20497# 0.00155f
C225 a_66605_20638# a_95605_20497# 0.36836f
C226 a_88645_20497# a_90037_20497# 31.7177f
C227 a_11489_20601# a_70323_3536# 0.07056f
C228 a_19151_20601# a_44347_3395# 5.33402f
C229 a_19151_20601# a_95605_20497# 0.08084f
C230 a_84469_20497# a_88645_20497# 0.00155f
C231 a_66605_20638# a_90037_20497# 0.34545f
C232 a_34533_20513# a_94213_20497# 0.19489f
C233 a_59341_20513# a_91429_20497# 0.06502f
C234 a_85861_20497# a_87253_20497# 30.5295f
C235 a_11489_20601# a_330_3570# 0.87841f
C236 a_11489_20601# a_91429_20497# 0.0753f
C237 a_19151_20601# a_90037_20497# 0.07703f
C238 a_66605_20638# a_84469_20497# 0.3724f
C239 a_59341_20513# a_85861_20497# 0.06468f
C240 a_48189_20638# a_87253_20497# 0.00351f
C241 a_34533_20513# a_88645_20497# 0.19392f
C242 a_11489_20601# a_85861_20497# 0.0753f
C243 a_43557_20638# a_73383_20638# 0.00142f
C244 a_19151_20601# a_84469_20497# 0.07736f
C245 a_34533_20513# a_66605_20638# 2.19522f
C246 a_48189_20638# a_59341_20513# 1.79711f
C247 a_11489_20601# a_48189_20638# 0.07578f
C248 a_22135_35889# a_73383_20638# 1.09675f
C249 a_46473_20638# a_55959_20601# 0.62559f
C250 a_19151_20601# a_34533_20513# 0.16672f
C251 a_95605_20497# VOUT 0.07727f
C252 a_42955_5395# a_44347_3395# 7.46583f
C253 a_20743_35889# a_26813_20601# 0.25833f
C254 a_330_3570# a_4610_3570# 1.1274f
C255 a_90037_20497# VOUT 0.07727f
C256 a_84469_20497# VOUT 0.07727f
C257 a_73383_20638# a_44347_3395# 0
C258 a_43557_20638# VIN 0.77077f
C259 a_34533_20513# VOUT 0.07764f
C260 a_73383_20638# a_95605_20497# 0.45413f
C261 a_34533_20513# a_42955_5395# 0.0867f
C262 a_26813_20601# a_94213_20497# 0.08718f
C263 a_73383_20638# a_90037_20497# 0.42347f
C264 a_55959_20601# a_91429_20497# 0.19415f
C265 a_43557_20638# a_92821_20497# 0.25991f
C266 a_20743_35889# a_94213_20497# 0.08742f
C267 a_55959_20601# a_85861_20497# 0.19405f
C268 a_43557_20638# a_87253_20497# 0.25873f
C269 a_26813_20601# a_88645_20497# 0.09664f
C270 a_73383_20638# a_84469_20497# 0.46326f
C271 a_26813_20601# a_66605_20638# 0.08745f
C272 a_20743_35889# a_88645_20497# 0.08747f
C273 a_46473_20638# a_85861_20497# 0
C274 a_43557_20638# a_59341_20513# 9.3405f
C275 a_199_20638# a_84469_20497# 0
C276 a_48189_20638# a_55959_20601# 0.96048f
C277 a_34533_20513# a_73383_20638# 2.75029f
C278 a_44347_3395# VIN 0.16421f
C279 a_11489_20601# a_43557_20638# 0.0791f
C280 a_22135_35889# a_59341_20513# 3.45794f
C281 a_20743_35889# a_66605_20638# 0.08747f
C282 a_199_20638# a_34533_20513# 0.24373f
C283 a_19151_20601# a_26813_20601# 45.9125f
C284 a_46473_20638# a_48189_20638# 12.2024f
C285 a_330_3570# a_70323_3536# 0.87644f
C286 a_38850_3570# a_44347_3395# 0.94396f
C287 a_95605_20497# VIN 0.08736f
C288 a_20743_35889# a_19151_20601# 0
C289 a_90037_20497# VIN 0.08356f
C290 a_92821_20497# a_95605_20497# 0.00356f
C291 a_84469_20497# VIN 0.08356f
C292 a_26813_20601# VOUT 0.22872f
C293 a_34533_20513# VIN 1.74221f
C294 a_87253_20497# a_95605_20497# 0
C295 a_88645_20497# a_94213_20497# 0
C296 a_90037_20497# a_92821_20497# 0.00356f
C297 VIN VSS 1.43763p
C298 a_70323_3536# VSS 94.94215f
C299 a_44347_3395# VSS 14.7806f
C300 a_38850_3570# VSS 4.41249f
C301 a_4610_3570# VSS 65.6899f
C302 a_330_3570# VSS 3.82525f
C303 a_95605_20497# VSS 29.1738f
C304 a_94213_20497# VSS 20.9155f
C305 a_92821_20497# VSS 20.4993f
C306 a_91429_20497# VSS 20.0833f
C307 a_90037_20497# VSS 19.6482f
C308 a_88645_20497# VSS 19.2301f
C309 a_87253_20497# VSS 18.7926f
C310 a_85861_20497# VSS 18.372f
C311 a_84469_20497# VSS 25.4843f
C312 a_73383_20638# VSS 0.24406p
C313 a_55959_20601# VSS 37.49255f
C314 a_19151_20601# VSS 13.17885f
C315 a_11489_20601# VSS 16.8741f
C316 a_46473_20638# VSS 12.6437f
C317 a_22135_35889# VSS 15.334f
.ends
