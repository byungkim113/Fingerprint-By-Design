* NGSPICE file created from ldo_blk.ext - technology: sky130A

.subckt ldo_blk VIN VOUT VSS
X0 VSS VSS a_4610_3570# sky130_fd_pr__pnp_05v5_W3p40L3p40
**devattr s=462400,2720
X1 VSS VSS a_4610_3570# sky130_fd_pr__pnp_05v5_W3p40L3p40
**devattr s=462400,2720
X2 a_42955_5395# a_4610_3570# VSS sky130_fd_pr__res_xhigh_po_1p41 l=8
X3 VIN a_73383_20158# a_48189_20158# VIN sky130_fd_pr__pfet_g5v0d10v5 ad=1.45 pd=10.29 as=2.9 ps=20.58 w=10 l=0.5
X4 VSS a_11489_20121# a_11489_20121# VSS sky130_fd_pr__nfet_g5v0d10v5 ad=4.64 pd=32.58 as=4.64 ps=32.58 w=16 l=32
X5 VIN VSS a_66605_20158# VIN sky130_fd_pr__pfet_g5v0d10v5 ad=0.1218 pd=1.42 as=0.1218 ps=1.42 w=0.42 l=20
X6 VIN a_26813_20121# a_70323_3536# VIN sky130_fd_pr__pfet_g5v0d10v5 ad=4.64 pd=32.58 as=4.64 ps=32.58 w=16 l=32
X7 VIN a_46473_20158# a_46473_20158# VIN sky130_fd_pr__pfet_g5v0d10v5 ad=5.8 pd=40.58 as=5.8 ps=40.58 w=20 l=2
X8 a_48189_20158# a_73383_20158# VIN VIN sky130_fd_pr__pfet_g5v0d10v5 ad=1.45 pd=10.29 as=1.45 ps=10.29 w=10 l=0.5
X9 a_155_42859# a_155_35409# VSS sky130_fd_pr__res_xhigh_po_1p41 l=35.25
X10 a_34533_20033# a_44347_3395# VSS sky130_fd_pr__res_xhigh_po_1p41 l=39
X11 VOUT a_48189_20158# VIN VIN sky130_fd_pr__pfet_g5v0d10v5 ad=1.45 pd=10.29 as=1.45 ps=10.29 w=10 l=0.5
X12 a_48189_20158# VOUT sky130_fd_pr__cap_mim_m3_1 l=22 w=22
X13 VIN a_48189_20158# VOUT VIN sky130_fd_pr__pfet_g5v0d10v5 ad=1.45 pd=10.29 as=1.45 ps=10.29 w=10 l=0.5
X14 VSS VSS a_4610_3570# sky130_fd_pr__pnp_05v5_W3p40L3p40
**devattr s=462400,2720
X15 VSS VSS a_4610_3570# sky130_fd_pr__pnp_05v5_W3p40L3p40
**devattr s=462400,2720
X16 a_11563_35409# VSS VSS sky130_fd_pr__res_xhigh_po_1p41 l=35.25
X17 VIN a_26813_20121# a_26813_20121# VIN sky130_fd_pr__pfet_g5v0d10v5 ad=4.64 pd=32.58 as=4.64 ps=32.58 w=16 l=32
X18 VIN a_46473_20158# a_48189_20158# VIN sky130_fd_pr__pfet_g5v0d10v5 ad=5.8 pd=40.58 as=5.8 ps=40.58 w=20 l=2
X19 a_26813_20121# a_19151_20121# sky130_fd_pr__cap_mim_m3_1 l=22 w=22
X20 a_155_35409# a_1547_35409# VSS sky130_fd_pr__res_xhigh_po_1p41 l=35.25
X21 VSS VSS a_38850_3570# sky130_fd_pr__pnp_05v5_W3p40L3p40
**devattr s=462400,2720
X22 VSS VSS a_4610_3570# sky130_fd_pr__pnp_05v5_W3p40L3p40
**devattr s=462400,2720
X23 VSS VSS a_38850_3570# sky130_fd_pr__pnp_05v5_W3p40L3p40
**devattr s=462400,2720
X24 a_55959_20121# a_10171_35409# a_46473_20158# VSS sky130_fd_pr__nfet_g5v0d10v5 ad=5.8 pd=40.58 as=5.8 ps=40.58 w=20 l=2
X25 VSS VOUT VSS VSS sky130_fd_pr__nfet_01v8 ad=5.8 pd=40.58 as=302.16 ps=1.9294k w=20 l=20
X26 VSS VSS a_330_3570# sky130_fd_pr__pnp_05v5_W3p40L3p40
**devattr s=462400,2720
X27 VSS a_43557_20158# a_43557_20158# VSS sky130_fd_pr__nfet_g5v0d10v5 ad=1.16 pd=8.58 as=1.16 ps=8.58 w=4 l=2
X28 VOUT a_48189_20158# VIN VIN sky130_fd_pr__pfet_g5v0d10v5 ad=1.45 pd=10.29 as=1.45 ps=10.29 w=10 l=0.5
X29 VIN a_26813_20121# a_43557_20158# VIN sky130_fd_pr__pfet_g5v0d10v5 ad=1.16 pd=8.58 as=1.16 ps=8.58 w=4 l=8
X30 VSS VSS a_330_3570# sky130_fd_pr__pnp_05v5_W3p40L3p40
**devattr s=462400,2720
X31 VOUT a_48189_20158# VIN VIN sky130_fd_pr__pfet_g5v0d10v5 ad=1.45 pd=10.29 as=1.45 ps=10.29 w=10 l=0.5
X32 VSS VOUT VSS VSS sky130_fd_pr__nfet_01v8 ad=5.8 pd=40.58 as=0 ps=0 w=20 l=20
X33 VSS VOUT VSS VSS sky130_fd_pr__nfet_01v8 ad=5.8 pd=40.58 as=0 ps=0 w=20 l=20
X34 VIN a_48189_20158# VOUT VIN sky130_fd_pr__pfet_g5v0d10v5 ad=1.45 pd=10.29 as=1.45 ps=10.29 w=10 l=0.5
X35 VSS VSS a_4610_3570# sky130_fd_pr__pnp_05v5_W3p40L3p40
**devattr s=462400,2720
X36 VSS VSS a_4610_3570# sky130_fd_pr__pnp_05v5_W3p40L3p40
**devattr s=462400,2720
X37 VIN a_48189_20158# VOUT VIN sky130_fd_pr__pfet_g5v0d10v5 ad=1.45 pd=10.29 as=1.45 ps=10.29 w=10 l=0.5
X38 VOUT a_48189_20158# VIN VIN sky130_fd_pr__pfet_g5v0d10v5 ad=1.45 pd=10.29 as=1.45 ps=10.29 w=10 l=0.5
X39 VIN a_48189_20158# VOUT VIN sky130_fd_pr__pfet_g5v0d10v5 ad=1.45 pd=10.29 as=1.45 ps=10.29 w=10 l=0.5
X40 VSS VOUT VSS VSS sky130_fd_pr__nfet_01v8 ad=5.8 pd=40.58 as=0 ps=0 w=20 l=20
X41 VIN a_26813_20121# a_42955_5395# VIN sky130_fd_pr__pfet_g5v0d10v5 ad=4.64 pd=32.58 as=4.64 ps=32.58 w=16 l=32
X42 a_70323_3536# a_42955_5395# a_19151_20121# VIN sky130_fd_pr__pfet_g5v0d10v5 ad=2.32 pd=16.58 as=2.32 ps=16.58 w=8 l=16
X43 VSS VOUT VSS VSS sky130_fd_pr__nfet_01v8 ad=5.8 pd=40.58 as=0 ps=0 w=20 l=20
X44 VSS a_34533_20033# a_66605_20158# VSS sky130_fd_pr__nfet_g5v0d10v5 ad=0.58 pd=4.58 as=0.58 ps=4.58 w=2 l=1
X45 VSS VOUT VSS VSS sky130_fd_pr__nfet_01v8 ad=5.8 pd=40.58 as=0 ps=0 w=20 l=20
X46 VSS VSS a_4610_3570# sky130_fd_pr__pnp_05v5_W3p40L3p40
**devattr s=462400,2720
X47 VIN a_48189_20158# VOUT VIN sky130_fd_pr__pfet_g5v0d10v5 ad=1.45 pd=10.29 as=1.45 ps=10.29 w=10 l=0.5
X48 VOUT a_48189_20158# VIN VIN sky130_fd_pr__pfet_g5v0d10v5 ad=2.9 pd=20.58 as=1.45 ps=10.29 w=10 l=0.5
X49 VSS a_199_20158# a_26813_20121# VSS sky130_fd_pr__nfet_g5v0d10v5 ad=0.145 pd=1.58 as=0.145 ps=1.58 w=0.5 l=4
X50 VIN a_73383_20158# a_48189_20158# VIN sky130_fd_pr__pfet_g5v0d10v5 ad=1.45 pd=10.29 as=1.45 ps=10.29 w=10 l=0.5
X51 VSS VOUT VSS VSS sky130_fd_pr__nfet_01v8 ad=5.8 pd=40.58 as=0 ps=0 w=20 l=20
X52 VIN a_48189_20158# VOUT VIN sky130_fd_pr__pfet_g5v0d10v5 ad=1.45 pd=10.29 as=1.45 ps=10.29 w=10 l=0.5
X53 VSS a_11489_20121# a_19151_20121# VSS sky130_fd_pr__nfet_g5v0d10v5 ad=4.64 pd=32.58 as=4.64 ps=32.58 w=16 l=32
X54 VSS VSS a_4610_3570# sky130_fd_pr__pnp_05v5_W3p40L3p40
**devattr s=462400,2720
X55 a_48189_20158# a_73383_20158# VIN VIN sky130_fd_pr__pfet_g5v0d10v5 ad=2.9 pd=20.58 as=1.45 ps=10.29 w=10 l=0.5
X56 VSS VSS a_4610_3570# sky130_fd_pr__pnp_05v5_W3p40L3p40
**devattr s=462400,2720
X57 a_88645_20017# a_90037_20017# VSS sky130_fd_pr__res_xhigh_po_1p41 l=35.25
X58 VOUT a_48189_20158# VIN VIN sky130_fd_pr__pfet_g5v0d10v5 ad=1.45 pd=10.29 as=1.45 ps=10.29 w=10 l=0.5
X59 a_1547_35409# VSS sky130_fd_pr__cap_mim_m3_1 l=30 w=30
X60 VOUT a_48189_20158# VIN VIN sky130_fd_pr__pfet_g5v0d10v5 ad=1.45 pd=10.29 as=1.45 ps=10.29 w=10 l=0.5
X61 a_34533_20033# a_84469_20017# VSS sky130_fd_pr__res_xhigh_po_1p41 l=35.25
X62 a_84469_20017# a_85861_20017# VSS sky130_fd_pr__res_xhigh_po_1p41 l=35.25
X63 VIN a_66605_20158# a_73383_20158# VIN sky130_fd_pr__pfet_g5v0d10v5 ad=0.58 pd=4.58 as=0.58 ps=4.58 w=2 l=0.5
X64 VSS VOUT VSS VSS sky130_fd_pr__nfet_01v8 ad=5.8 pd=40.58 as=0 ps=0 w=20 l=20
X65 VSS VOUT VSS VSS sky130_fd_pr__nfet_01v8 ad=5.8 pd=40.58 as=0 ps=0 w=20 l=20
X66 a_70323_3536# a_330_3570# a_11489_20121# VIN sky130_fd_pr__pfet_g5v0d10v5 ad=2.32 pd=16.58 as=2.32 ps=16.58 w=8 l=16
X67 VSS VOUT VSS VSS sky130_fd_pr__nfet_01v8 ad=5.8 pd=40.58 as=0 ps=0 w=20 l=20
X68 a_73383_20158# VSS sky130_fd_pr__cap_mim_m3_1 l=10 w=10
X69 a_55959_20121# a_1547_35409# a_48189_20158# VSS sky130_fd_pr__nfet_g5v0d10v5 ad=5.8 pd=40.58 as=5.8 ps=40.58 w=20 l=2
X70 VSS VSS a_4610_3570# sky130_fd_pr__pnp_05v5_W3p40L3p40
**devattr s=462400,2720
X71 VIN VSS a_199_20158# VIN sky130_fd_pr__pfet_g5v0d10v5 ad=0.1218 pd=1.42 as=0.1218 ps=1.42 w=0.42 l=50
X72 VOUT a_10171_35409# VSS sky130_fd_pr__res_xhigh_po_1p41 l=34.1
X73 VIN a_48189_20158# VOUT VIN sky130_fd_pr__pfet_g5v0d10v5 ad=1.45 pd=10.29 as=2.9 ps=20.58 w=10 l=0.5
X74 a_85861_20017# a_87253_20017# VSS sky130_fd_pr__res_xhigh_po_1p41 l=35.25
X75 VIN a_26813_20121# a_330_3570# VIN sky130_fd_pr__pfet_g5v0d10v5 ad=4.64 pd=32.58 as=4.64 ps=32.58 w=16 l=32
X76 VSS VOUT VSS VSS sky130_fd_pr__nfet_01v8 ad=5.8 pd=40.58 as=0 ps=0 w=20 l=20
X77 VSS VOUT VSS VSS sky130_fd_pr__nfet_01v8 ad=5.8 pd=40.58 as=0 ps=0 w=20 l=20
X78 VIN a_26813_20121# a_34533_20033# VIN sky130_fd_pr__pfet_g5v0d10v5 ad=4.64 pd=32.58 as=4.64 ps=32.58 w=16 l=32
X79 VSS VSS a_4610_3570# sky130_fd_pr__pnp_05v5_W3p40L3p40
**devattr s=462400,2720
X80 VSS VSS a_4610_3570# sky130_fd_pr__pnp_05v5_W3p40L3p40
**devattr s=462400,2720
X81 VOUT a_48189_20158# VIN VIN sky130_fd_pr__pfet_g5v0d10v5 ad=1.45 pd=10.29 as=1.45 ps=10.29 w=10 l=0.5
X82 VSS VOUT VSS VSS sky130_fd_pr__nfet_01v8 ad=5.8 pd=40.58 as=0 ps=0 w=20 l=20
X83 a_90037_20017# a_91429_20017# VSS sky130_fd_pr__res_xhigh_po_1p41 l=35.25
X84 a_91429_20017# a_92821_20017# VSS sky130_fd_pr__res_xhigh_po_1p41 l=35.25
X85 VSS a_66605_20158# a_73383_20158# VSS sky130_fd_pr__nfet_g5v0d10v5 ad=0.29 pd=2.58 as=0.29 ps=2.58 w=1 l=0.5
X86 a_44347_3395# a_38850_3570# VSS sky130_fd_pr__res_xhigh_po_1p41 l=39
X87 VSS a_34533_20033# a_199_20158# VSS sky130_fd_pr__nfet_g5v0d10v5 ad=1.16 pd=8.58 as=1.16 ps=8.58 w=4 l=0.5
X88 VSS VSS a_4610_3570# sky130_fd_pr__pnp_05v5_W3p40L3p40
**devattr s=462400,2720
X89 VSS VOUT VSS VSS sky130_fd_pr__nfet_01v8 ad=5.8 pd=40.58 as=0 ps=0 w=20 l=20
X90 VOUT a_48189_20158# VIN VIN sky130_fd_pr__pfet_g5v0d10v5 ad=1.45 pd=10.29 as=1.45 ps=10.29 w=10 l=0.5
X91 VSS VOUT VSS VSS sky130_fd_pr__nfet_01v8 ad=5.8 pd=40.58 as=0 ps=0 w=20 l=20
X92 VSS VSS a_4610_3570# sky130_fd_pr__pnp_05v5_W3p40L3p40
**devattr s=462400,2720
X93 VOUT a_48189_20158# VIN VIN sky130_fd_pr__pfet_g5v0d10v5 ad=1.45 pd=10.29 as=1.45 ps=10.29 w=10 l=0.5
X94 VIN a_48189_20158# VOUT VIN sky130_fd_pr__pfet_g5v0d10v5 ad=1.45 pd=10.29 as=1.45 ps=10.29 w=10 l=0.5
X95 VSS a_43557_20158# a_55959_20121# VSS sky130_fd_pr__nfet_g5v0d10v5 ad=2.32 pd=16.58 as=2.32 ps=16.58 w=8 l=2
X96 VSS a_19151_20121# a_26813_20121# VSS sky130_fd_pr__nfet_g5v0d10v5 ad=4.64 pd=32.58 as=4.64 ps=32.58 w=16 l=32
X97 a_66605_20158# VIN sky130_fd_pr__cap_mim_m3_1 l=10 w=10
X98 VIN a_48189_20158# VOUT VIN sky130_fd_pr__pfet_g5v0d10v5 ad=1.45 pd=10.29 as=1.45 ps=10.29 w=10 l=0.5
X99 a_92821_20017# a_155_42859# VSS sky130_fd_pr__res_xhigh_po_1p41 l=35.25
X100 VIN a_48189_20158# VOUT VIN sky130_fd_pr__pfet_g5v0d10v5 ad=1.45 pd=10.29 as=1.45 ps=10.29 w=10 l=0.5
X101 a_10171_35409# a_11563_35409# VSS sky130_fd_pr__res_xhigh_po_1p41 l=35.25
X102 VSS VSS a_4610_3570# sky130_fd_pr__pnp_05v5_W3p40L3p40
**devattr s=462400,2720
X103 a_87253_20017# a_88645_20017# VSS sky130_fd_pr__res_xhigh_po_1p41 l=35.25
C0 a_85861_20017# a_199_20158# 0
C1 a_34533_20033# a_10171_35409# 0.1521f
C2 a_73383_20158# a_11489_20121# 0.08064f
C3 a_34533_20033# a_155_42859# 0.10057f
C4 a_85861_20017# a_34533_20033# 0.19392f
C5 a_46473_20158# a_87253_20017# 0
C6 a_44347_3395# a_4610_3570# 0.03652f
C7 a_88645_20017# a_55959_20121# 0.19411f
C8 a_43557_20158# a_90037_20017# 0.25953f
C9 a_43557_20158# a_19151_20121# 0.10391f
C10 a_66605_20158# a_87253_20017# 0.34545f
C11 VIN a_4610_3570# 1.61225f
C12 a_90037_20017# a_26813_20121# 0.09517f
C13 VIN a_55959_20121# 0.20683f
C14 a_26813_20121# a_19151_20121# 45.8972f
C15 a_43557_20158# a_11489_20121# 0.0791f
C16 a_90037_20017# a_84469_20017# 0
C17 a_84469_20017# a_19151_20121# 0.07736f
C18 a_91429_20017# a_73383_20158# 0.42373f
C19 VOUT a_55959_20121# 0.24765f
C20 a_42955_5395# a_4610_3570# 7.017f
C21 a_26813_20121# a_11489_20121# 0.26011f
C22 a_92821_20017# a_55959_20121# 0.19445f
C23 a_48189_20158# a_46473_20158# 12.2026f
C24 a_84469_20017# a_11489_20121# 0.07535f
C25 a_55959_20121# a_1547_35409# 1.64711f
C26 a_38850_3570# a_4610_3570# 0.14325f
C27 a_48189_20158# a_66605_20158# 0.17808f
C28 a_199_20158# a_19151_20121# 11.8271f
C29 a_26813_20121# a_70323_3536# 2.99072f
C30 a_43557_20158# a_91429_20017# 0.26033f
C31 a_73383_20158# a_155_35409# 0
C32 a_88645_20017# a_46473_20158# 0
C33 a_90037_20017# a_34533_20033# 0.19432f
C34 a_199_20158# a_11489_20121# 0.14275f
C35 a_19151_20121# a_34533_20033# 0.16672f
C36 a_55959_20121# a_10171_35409# 1.64705f
C37 a_91429_20017# a_26813_20121# 0.0875f
C38 a_330_3570# a_44347_3395# 0.14323f
C39 a_55959_20121# a_155_42859# 0.79095f
C40 a_91429_20017# a_84469_20017# 0
C41 a_43557_20158# a_73383_20158# 0.00239f
C42 a_88645_20017# a_66605_20158# 0.34545f
C43 a_11489_20121# a_34533_20033# 0.15116f
C44 a_66605_20158# a_44347_3395# 0
C45 VIN a_46473_20158# 7.38053f
C46 a_85861_20017# a_55959_20121# 0.19405f
C47 VIN a_330_3570# 15.8637f
C48 a_26813_20121# a_73383_20158# 1.09438f
C49 VOUT a_46473_20158# 0.20797f
C50 a_84469_20017# a_73383_20158# 0.46326f
C51 VIN a_66605_20158# 10.2405f
C52 a_330_3570# a_42955_5395# 23.0454f
C53 VOUT a_66605_20158# 0.08523f
C54 a_92821_20017# a_66605_20158# 0.35786f
C55 a_66605_20158# a_1547_35409# 10.3437f
C56 a_91429_20017# a_34533_20033# 0.19461f
C57 a_38850_3570# a_330_3570# 0.21951f
C58 a_43557_20158# a_26813_20121# 0.54807f
C59 a_43557_20158# a_84469_20017# 0.27469f
C60 a_46473_20158# a_10171_35409# 9.56046f
C61 a_48189_20158# a_87253_20017# 0.00351f
C62 a_73383_20158# a_34533_20033# 2.75029f
C63 a_26813_20121# a_84469_20017# 14.7509f
C64 a_85861_20017# a_46473_20158# 0
C65 a_66605_20158# a_10171_35409# 0.08742f
C66 a_90037_20017# a_55959_20121# 0.19415f
C67 a_19151_20121# a_4610_3570# 0.00763f
C68 a_66605_20158# a_155_42859# 0.93843f
C69 a_85861_20017# a_66605_20158# 0.34545f
C70 a_88645_20017# a_87253_20017# 31.1236f
C71 a_11489_20121# a_4610_3570# 5.92097f
C72 a_26813_20121# a_199_20158# 0.17083f
C73 a_43557_20158# a_34533_20033# 12.613f
C74 a_84469_20017# a_199_20158# 0
C75 VIN a_87253_20017# 0.08356f
C76 a_26813_20121# a_34533_20033# 19.6265f
C77 a_84469_20017# a_34533_20033# 0.26298f
C78 VOUT a_87253_20017# 0.07727f
C79 a_92821_20017# a_87253_20017# 0
C80 a_1547_35409# a_87253_20017# 0.06468f
C81 a_48189_20158# a_88645_20017# 0.00224f
C82 a_91429_20017# a_55959_20121# 0.19422f
C83 a_19151_20121# a_46473_20158# 0.71001f
C84 a_199_20158# a_34533_20033# 0.24376f
C85 a_66605_20158# a_11563_35409# 0
C86 a_48189_20158# VIN 20.6004f
C87 a_330_3570# a_19151_20121# 0.00102f
C88 a_73383_20158# a_55959_20121# 0
C89 a_90037_20017# a_66605_20158# 0.34568f
C90 VOUT a_48189_20158# 51.0074f
C91 a_11489_20121# a_46473_20158# 0.07649f
C92 a_66605_20158# a_19151_20121# 0.07703f
C93 a_10171_35409# a_87253_20017# 0.09496f
C94 a_330_3570# a_11489_20121# 0.87841f
C95 a_155_42859# a_87253_20017# 0
C96 a_48189_20158# a_1547_35409# 1.79711f
C97 a_66605_20158# a_11489_20121# 0.0753f
C98 a_85861_20017# a_87253_20017# 30.5295f
C99 VIN a_88645_20017# 0.08356f
C100 VIN a_44347_3395# 0.16421f
C101 a_43557_20158# a_55959_20121# 0.68297f
C102 VOUT a_88645_20017# 0.07727f
C103 a_330_3570# a_70323_3536# 0.87644f
C104 a_44347_3395# a_42955_5395# 7.46583f
C105 a_92821_20017# a_88645_20017# 0.00155f
C106 a_26813_20121# a_4610_3570# 0
C107 a_88645_20017# a_1547_35409# 0.06478f
C108 a_48189_20158# a_10171_35409# 10.6326f
C109 a_84469_20017# a_55959_20121# 0.20602f
C110 VOUT VIN 30.4133f
C111 VIN a_42955_5395# 8.39397f
C112 a_38850_3570# a_44347_3395# 0.94396f
C113 a_92821_20017# VIN 0.08356f
C114 a_91429_20017# a_66605_20158# 0.34578f
C115 VIN a_1547_35409# 0.05447f
C116 a_48189_20158# a_85861_20017# 0.00627f
C117 VOUT a_92821_20017# 0.07727f
C118 VOUT a_1547_35409# 0.41524f
C119 VIN a_38850_3570# 0.27716f
C120 a_88645_20017# a_10171_35409# 0.08747f
C121 a_66605_20158# a_73383_20158# 29.1477f
C122 a_92821_20017# a_1547_35409# 0.06909f
C123 a_88645_20017# a_155_42859# 0
C124 a_38850_3570# a_42955_5395# 0.1997f
C125 a_85861_20017# a_88645_20017# 0.00356f
C126 a_90037_20017# a_87253_20017# 0.00356f
C127 a_19151_20121# a_87253_20017# 0.07703f
C128 VIN a_10171_35409# 0.05447f
C129 a_66605_20158# a_155_35409# 0
C130 VIN a_155_42859# 0.08736f
C131 a_43557_20158# a_46473_20158# 0.15939f
C132 VOUT a_10171_35409# 2.20546f
C133 a_11489_20121# a_87253_20017# 0.0753f
C134 VIN a_85861_20017# 0.08356f
C135 VOUT a_155_42859# 0.09089f
C136 a_26813_20121# a_46473_20158# 0.30472f
C137 a_92821_20017# a_10171_35409# 0.08742f
C138 a_43557_20158# a_66605_20158# 9.33897f
C139 a_84469_20017# a_46473_20158# 0.00133f
C140 a_10171_35409# a_1547_35409# 0.36169f
C141 a_26813_20121# a_330_3570# 2.07457f
C142 a_92821_20017# a_155_42859# 18.0219f
C143 VOUT a_85861_20017# 0.07727f
C144 a_1547_35409# a_155_42859# 0.25506f
C145 a_26813_20121# a_66605_20158# 0.08745f
C146 a_92821_20017# a_85861_20017# 0
C147 a_85861_20017# a_1547_35409# 0.06468f
C148 a_66605_20158# a_84469_20017# 0.3724f
C149 a_48189_20158# a_90037_20017# 0.00147f
C150 a_48189_20158# a_19151_20121# 0.08686f
C151 a_199_20158# a_46473_20158# 13.6176f
C152 a_48189_20158# a_11489_20121# 0.07578f
C153 a_91429_20017# a_87253_20017# 0.00155f
C154 a_10171_35409# a_155_42859# 0.06608f
C155 a_34533_20033# a_46473_20158# 0.06468f
C156 a_90037_20017# a_88645_20017# 31.7177f
C157 a_85861_20017# a_10171_35409# 0.09618f
C158 a_88645_20017# a_19151_20121# 0.07703f
C159 a_19151_20121# a_44347_3395# 5.33402f
C160 a_85861_20017# a_155_42859# 0
C161 a_330_3570# a_34533_20033# 0.07694f
C162 a_73383_20158# a_87253_20017# 0.42347f
C163 a_66605_20158# a_34533_20033# 3.76864f
C164 VOUT a_11563_35409# 0.27108f
C165 a_88645_20017# a_11489_20121# 0.0753f
C166 a_90037_20017# VIN 0.08356f
C167 a_44347_3395# a_11489_20121# 0.15105f
C168 VIN a_19151_20121# 2.58152f
C169 VOUT a_90037_20017# 0.07727f
C170 a_11563_35409# a_1547_35409# 0.49599f
C171 VOUT a_19151_20121# 0.25516f
C172 a_19151_20121# a_42955_5395# 0.878f
C173 VIN a_11489_20121# 4.04712f
C174 a_92821_20017# a_90037_20017# 0.00356f
C175 a_92821_20017# a_19151_20121# 0.07703f
C176 a_90037_20017# a_1547_35409# 0.06483f
C177 a_43557_20158# a_87253_20017# 0.2589f
C178 VOUT a_11489_20121# 0.1941f
C179 a_42955_5395# a_11489_20121# 3.26869f
C180 a_48189_20158# a_73383_20158# 1.79301f
C181 a_92821_20017# a_11489_20121# 0.0753f
C182 a_38850_3570# a_19151_20121# 1.23788f
C183 a_26813_20121# a_87253_20017# 0.099f
C184 a_91429_20017# a_88645_20017# 0.00356f
C185 a_84469_20017# a_87253_20017# 0.00356f
C186 VIN a_70323_3536# 3.45988f
C187 a_11563_35409# a_10171_35409# 5.09961f
C188 a_11563_35409# a_155_42859# 0.70008f
C189 a_38850_3570# a_11489_20121# 0.19846f
C190 a_90037_20017# a_10171_35409# 0.08742f
C191 a_70323_3536# a_42955_5395# 0.87649f
C192 a_19151_20121# a_10171_35409# 0
C193 a_91429_20017# VIN 0.08356f
C194 a_90037_20017# a_155_42859# 0
C195 a_88645_20017# a_73383_20158# 0.42347f
C196 a_19151_20121# a_155_42859# 0.08084f
C197 a_44347_3395# a_73383_20158# 0
C198 a_48189_20158# a_43557_20158# 0.4028f
C199 VOUT a_91429_20017# 0.07727f
C200 a_90037_20017# a_85861_20017# 0.00155f
C201 a_11489_20121# a_10171_35409# 0
C202 a_85861_20017# a_19151_20121# 0.07717f
C203 a_55959_20121# a_46473_20158# 0.62554f
C204 a_199_20158# a_87253_20017# 0
C205 a_11489_20121# a_155_42859# 0.0791f
C206 a_92821_20017# a_91429_20017# 32.906f
C207 a_330_3570# a_4610_3570# 1.1274f
C208 a_48189_20158# a_26813_20121# 15.785f
C209 VIN a_73383_20158# 3.56557f
C210 a_91429_20017# a_1547_35409# 0.06491f
C211 a_48189_20158# a_84469_20017# 4.60454f
C212 a_85861_20017# a_11489_20121# 0.0753f
C213 a_34533_20033# a_87253_20017# 0.19405f
C214 VOUT a_73383_20158# 0.08261f
C215 a_66605_20158# a_55959_20121# 0.29904f
C216 a_42955_5395# a_73383_20158# 0
C217 a_43557_20158# a_88645_20017# 0.25921f
C218 a_92821_20017# a_73383_20158# 0.44361f
C219 a_73383_20158# a_1547_35409# 0.46268f
C220 VOUT a_155_35409# 0.16992f
C221 a_26813_20121# a_88645_20017# 0.09664f
C222 a_26813_20121# a_44347_3395# 11.5203f
C223 a_91429_20017# a_10171_35409# 0.08742f
C224 a_88645_20017# a_84469_20017# 0.00155f
C225 a_43557_20158# VIN 0.77078f
C226 a_48189_20158# a_199_20158# 0.00272f
C227 a_155_35409# a_1547_35409# 2.85937f
C228 a_91429_20017# a_155_42859# 0.00228f
C229 VOUT a_43557_20158# 0.24814f
C230 VIN a_26813_20121# 73.6454f
C231 a_91429_20017# a_85861_20017# 0
C232 a_48189_20158# a_34533_20033# 0.06468f
C233 VIN a_84469_20017# 0.08356f
C234 a_73383_20158# a_10171_35409# 0.09279f
C235 a_43557_20158# a_92821_20017# 9.77549f
C236 a_43557_20158# a_1547_35409# 0.00173f
C237 VOUT a_26813_20121# 0.22872f
C238 a_73383_20158# a_155_42859# 0.3433f
C239 a_26813_20121# a_42955_5395# 4.80836f
C240 VOUT a_84469_20017# 0.07727f
C241 a_90037_20017# a_19151_20121# 0.07703f
C242 a_92821_20017# a_26813_20121# 0.08718f
C243 a_85861_20017# a_73383_20158# 0.42347f
C244 a_92821_20017# a_84469_20017# 0
C245 a_10171_35409# a_155_35409# 0.21821f
C246 a_84469_20017# a_1547_35409# 0.06867f
C247 a_155_35409# a_155_42859# 2.85613f
C248 a_90037_20017# a_11489_20121# 0.0753f
C249 a_19151_20121# a_11489_20121# 25.7676f
C250 a_88645_20017# a_34533_20033# 0.19411f
C251 a_44347_3395# a_34533_20033# 0.10124f
C252 a_26813_20121# a_38850_3570# 0.07343f
C253 VIN a_199_20158# 0.38297f
C254 a_43557_20158# a_10171_35409# 0.23824f
C255 VOUT a_199_20158# 0.20533f
C256 a_43557_20158# a_155_42859# 6.3672f
C257 VIN a_34533_20033# 1.74223f
C258 a_55959_20121# a_87253_20017# 0.19409f
C259 a_26813_20121# a_10171_35409# 0.25816f
C260 a_43557_20158# a_85861_20017# 0.25885f
C261 a_26813_20121# a_155_42859# 0.09099f
C262 a_19151_20121# a_70323_3536# 1.24706f
C263 a_84469_20017# a_10171_35409# 0.09805f
C264 VOUT a_34533_20033# 0.07764f
C265 a_84469_20017# a_155_42859# 0
C266 a_42955_5395# a_34533_20033# 0.0867f
C267 a_92821_20017# a_34533_20033# 2.392f
C268 a_85861_20017# a_26813_20121# 0.10361f
C269 a_34533_20033# a_1547_35409# 10.2462f
C270 a_91429_20017# a_90037_20017# 32.3118f
C271 a_70323_3536# a_11489_20121# 0.07056f
C272 a_91429_20017# a_19151_20121# 0.07703f
C273 a_85861_20017# a_84469_20017# 29.9354f
C274 a_11563_35409# a_73383_20158# 0.27265f
C275 a_38850_3570# a_34533_20033# 0
C276 a_91429_20017# a_11489_20121# 0.0753f
C277 a_199_20158# a_10171_35409# 0.00128f
C278 a_90037_20017# a_73383_20158# 0.42347f
C279 a_48189_20158# a_55959_20121# 0.96048f
C280 a_19151_20121# a_73383_20158# 0.08237f
C281 a_11563_35409# a_155_35409# 0.87723f
C282 VIN VSS 0.80837p
C283 a_70323_3536# VSS 0.16778p
C284 a_44347_3395# VSS 14.7806f
C285 a_38850_3570# VSS 4.41249f
C286 a_4610_3570# VSS 0.12428p
C287 a_330_3570# VSS 3.82527f
C288 a_92821_20017# VSS 23.4308f
C289 a_91429_20017# VSS 20.0834f
C290 a_90037_20017# VSS 19.648f
C291 a_88645_20017# VSS 19.2304f
C292 a_87253_20017# VSS 18.7926f
C293 a_85861_20017# VSS 18.3722f
C294 a_84469_20017# VSS 25.4844f
C295 a_55959_20121# VSS 19.87891f
C296 a_26813_20121# VSS 34.23668f
C297 a_11489_20121# VSS 0.10339p
C298 a_46473_20158# VSS 9.882f
C299 a_11563_35409# VSS 10.6874f
C300 a_155_35409# VSS 5.27101f
C301 a_155_42859# VSS 22.8971f
.ends
