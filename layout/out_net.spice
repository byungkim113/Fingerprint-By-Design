.subckt out_net OUTP OUTN RFP RFN IREF_PA VDD VSS
XRLp VDD OUTP VSS sky130_fd_pr__res_high_po_1p41 L=5.6 mult=1 m=1
XRLn VDD OUTN VSS sky130_fd_pr__res_high_po_1p41 L=5.6 mult=1 m=1
XCLp OUTP VSS sky130_fd_pr__cap_mim_m3_1 W=11 L=11 MF=1 m=1
XCLn OUTN VSS sky130_fd_pr__cap_mim_m3_1 W=11 L=11 MF=1 m=1
XCcp OUTP PG sky130_fd_pr__cap_mim_m3_1 W=30 L=30 MF=1 m=1
XCcn OUTN NG sky130_fd_pr__cap_mim_m3_1 W=30 L=30 MF=1 m=1
XRbp PG VB VSS sky130_fd_pr__res_xhigh_po_1p41 L=14.1 mult=1 m=1
XRbn NG VB VSS sky130_fd_pr__res_xhigh_po_1p41 L=14.1 mult=1 m=1
XRv1 VDD VB VSS sky130_fd_pr__res_xhigh_po_1p41 L=35.25 mult=1 m=1
XRv2 VB VSS VSS sky130_fd_pr__res_xhigh_po_1p41 L=35.25 mult=1 m=1
XPA1 RFN PG PTAIL VSS sky130_fd_pr__nfet_01v8 W=10 L=0.15 nf=1 m=1
XPA2 RFP NG PTAIL VSS sky130_fd_pr__nfet_01v8 W=10 L=0.15 nf=1 m=1
XRPAp VDD RFP VSS sky130_fd_pr__res_high_po_5p73 L=4.3 mult=1 m=1
XRPAn VDD RFN VSS sky130_fd_pr__res_high_po_5p73 L=4.3 mult=1 m=1
XPAB IREF_PA IREF_PA VSS VSS sky130_fd_pr__nfet_01v8 W=1 L=0.5 nf=1 m=1
XPAT PTAIL IREF_PA VSS VSS sky130_fd_pr__nfet_01v8 W=10 L=0.5 nf=1 m=1
.ends out_net
