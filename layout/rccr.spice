.subckt rccr IN VI VQ VSS
XRi IN VI VSS sky130_fd_pr__res_high_po_1p41 L=25.6 mult=1 m=1
XCi VI VSS sky130_fd_pr__cap_mim_m3_1 W=7.8 L=7.8 MF=1 m=1
XCq VQ IN sky130_fd_pr__cap_mim_m3_1 W=7.8 L=7.8 MF=1 m=1
XRq VQ VSS VSS sky130_fd_pr__res_high_po_1p41 L=20.3 mult=1 m=1
.ends rccr
