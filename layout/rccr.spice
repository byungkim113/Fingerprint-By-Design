.subckt rccr IN VI VQ VSS
XRi IN VI VSS sky130_fd_pr__res_high_po_0p35 L=5 mult=1 m=1
XCi VI VSS sky130_fd_pr__cap_mim_m3_1 W=7.8 L=7.8 MF=1 m=1
XCq IN VQ sky130_fd_pr__cap_mim_m3_1 W=7.8 L=7.8 MF=1 m=1
XRq VQ VSS VSS sky130_fd_pr__res_high_po_0p35 L=5 mult=1 m=1
.ends rccr
