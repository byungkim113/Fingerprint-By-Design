.subckt dac_mixer D0 DB0 D1 DB1 D2 DB2 D3 DB3 D4 DB4 D5 DB5 D6 DB6 D7 DB7 D8 DB8 D9 DB9 D10 DB10 D11 DB11 D12 DB12 D13 DB13 D14 DB14 D15 DB15 D16 DB16 D17 DB17 D18 DB18 D19 DB19 D20 DB20 D21 DB21 D22 DB22 D23 DB23 D24 DB24 D25 DB25 D26 DB26 D27 DB27 D28 DB28 D29 DB29 D30 DB30 OUTP OUTN LO LOB G VSS
XR G G VSS VSS sky130_fd_pr__nfet_01v8 W=0.5 L=1.0 nf=1 m=1
XU0 N0 G VSS VSS sky130_fd_pr__nfet_01v8 W=0.5 L=1.0 nf=1 m=1
XSP0 TP D0 N0 VSS sky130_fd_pr__nfet_01v8 W=1.0 L=0.15 nf=1 m=1
XSN0 TN DB0 N0 VSS sky130_fd_pr__nfet_01v8 W=1.0 L=0.15 nf=1 m=1
XU1 N1 G VSS VSS sky130_fd_pr__nfet_01v8 W=0.5 L=1.0 nf=1 m=1
XSP1 TP D1 N1 VSS sky130_fd_pr__nfet_01v8 W=1.0 L=0.15 nf=1 m=1
XSN1 TN DB1 N1 VSS sky130_fd_pr__nfet_01v8 W=1.0 L=0.15 nf=1 m=1
XU2 N2 G VSS VSS sky130_fd_pr__nfet_01v8 W=0.5 L=1.0 nf=1 m=1
XSP2 TP D2 N2 VSS sky130_fd_pr__nfet_01v8 W=1.0 L=0.15 nf=1 m=1
XSN2 TN DB2 N2 VSS sky130_fd_pr__nfet_01v8 W=1.0 L=0.15 nf=1 m=1
XU3 N3 G VSS VSS sky130_fd_pr__nfet_01v8 W=0.5 L=1.0 nf=1 m=1
XSP3 TP D3 N3 VSS sky130_fd_pr__nfet_01v8 W=1.0 L=0.15 nf=1 m=1
XSN3 TN DB3 N3 VSS sky130_fd_pr__nfet_01v8 W=1.0 L=0.15 nf=1 m=1
XU4 N4 G VSS VSS sky130_fd_pr__nfet_01v8 W=0.5 L=1.0 nf=1 m=1
XSP4 TP D4 N4 VSS sky130_fd_pr__nfet_01v8 W=1.0 L=0.15 nf=1 m=1
XSN4 TN DB4 N4 VSS sky130_fd_pr__nfet_01v8 W=1.0 L=0.15 nf=1 m=1
XU5 N5 G VSS VSS sky130_fd_pr__nfet_01v8 W=0.5 L=1.0 nf=1 m=1
XSP5 TP D5 N5 VSS sky130_fd_pr__nfet_01v8 W=1.0 L=0.15 nf=1 m=1
XSN5 TN DB5 N5 VSS sky130_fd_pr__nfet_01v8 W=1.0 L=0.15 nf=1 m=1
XU6 N6 G VSS VSS sky130_fd_pr__nfet_01v8 W=0.5 L=1.0 nf=1 m=1
XSP6 TP D6 N6 VSS sky130_fd_pr__nfet_01v8 W=1.0 L=0.15 nf=1 m=1
XSN6 TN DB6 N6 VSS sky130_fd_pr__nfet_01v8 W=1.0 L=0.15 nf=1 m=1
XU7 N7 G VSS VSS sky130_fd_pr__nfet_01v8 W=0.5 L=1.0 nf=1 m=1
XSP7 TP D7 N7 VSS sky130_fd_pr__nfet_01v8 W=1.0 L=0.15 nf=1 m=1
XSN7 TN DB7 N7 VSS sky130_fd_pr__nfet_01v8 W=1.0 L=0.15 nf=1 m=1
XU8 N8 G VSS VSS sky130_fd_pr__nfet_01v8 W=0.5 L=1.0 nf=1 m=1
XSP8 TP D8 N8 VSS sky130_fd_pr__nfet_01v8 W=1.0 L=0.15 nf=1 m=1
XSN8 TN DB8 N8 VSS sky130_fd_pr__nfet_01v8 W=1.0 L=0.15 nf=1 m=1
XU9 N9 G VSS VSS sky130_fd_pr__nfet_01v8 W=0.5 L=1.0 nf=1 m=1
XSP9 TP D9 N9 VSS sky130_fd_pr__nfet_01v8 W=1.0 L=0.15 nf=1 m=1
XSN9 TN DB9 N9 VSS sky130_fd_pr__nfet_01v8 W=1.0 L=0.15 nf=1 m=1
XU10 N10 G VSS VSS sky130_fd_pr__nfet_01v8 W=0.5 L=1.0 nf=1 m=1
XSP10 TP D10 N10 VSS sky130_fd_pr__nfet_01v8 W=1.0 L=0.15 nf=1 m=1
XSN10 TN DB10 N10 VSS sky130_fd_pr__nfet_01v8 W=1.0 L=0.15 nf=1 m=1
XU11 N11 G VSS VSS sky130_fd_pr__nfet_01v8 W=0.5 L=1.0 nf=1 m=1
XSP11 TP D11 N11 VSS sky130_fd_pr__nfet_01v8 W=1.0 L=0.15 nf=1 m=1
XSN11 TN DB11 N11 VSS sky130_fd_pr__nfet_01v8 W=1.0 L=0.15 nf=1 m=1
XU12 N12 G VSS VSS sky130_fd_pr__nfet_01v8 W=0.5 L=1.0 nf=1 m=1
XSP12 TP D12 N12 VSS sky130_fd_pr__nfet_01v8 W=1.0 L=0.15 nf=1 m=1
XSN12 TN DB12 N12 VSS sky130_fd_pr__nfet_01v8 W=1.0 L=0.15 nf=1 m=1
XU13 N13 G VSS VSS sky130_fd_pr__nfet_01v8 W=0.5 L=1.0 nf=1 m=1
XSP13 TP D13 N13 VSS sky130_fd_pr__nfet_01v8 W=1.0 L=0.15 nf=1 m=1
XSN13 TN DB13 N13 VSS sky130_fd_pr__nfet_01v8 W=1.0 L=0.15 nf=1 m=1
XU14 N14 G VSS VSS sky130_fd_pr__nfet_01v8 W=0.5 L=1.0 nf=1 m=1
XSP14 TP D14 N14 VSS sky130_fd_pr__nfet_01v8 W=1.0 L=0.15 nf=1 m=1
XSN14 TN DB14 N14 VSS sky130_fd_pr__nfet_01v8 W=1.0 L=0.15 nf=1 m=1
XU15 N15 G VSS VSS sky130_fd_pr__nfet_01v8 W=0.5 L=1.0 nf=1 m=1
XSP15 TP D15 N15 VSS sky130_fd_pr__nfet_01v8 W=1.0 L=0.15 nf=1 m=1
XSN15 TN DB15 N15 VSS sky130_fd_pr__nfet_01v8 W=1.0 L=0.15 nf=1 m=1
XU16 N16 G VSS VSS sky130_fd_pr__nfet_01v8 W=0.5 L=1.0 nf=1 m=1
XSP16 TP D16 N16 VSS sky130_fd_pr__nfet_01v8 W=1.0 L=0.15 nf=1 m=1
XSN16 TN DB16 N16 VSS sky130_fd_pr__nfet_01v8 W=1.0 L=0.15 nf=1 m=1
XU17 N17 G VSS VSS sky130_fd_pr__nfet_01v8 W=0.5 L=1.0 nf=1 m=1
XSP17 TP D17 N17 VSS sky130_fd_pr__nfet_01v8 W=1.0 L=0.15 nf=1 m=1
XSN17 TN DB17 N17 VSS sky130_fd_pr__nfet_01v8 W=1.0 L=0.15 nf=1 m=1
XU18 N18 G VSS VSS sky130_fd_pr__nfet_01v8 W=0.5 L=1.0 nf=1 m=1
XSP18 TP D18 N18 VSS sky130_fd_pr__nfet_01v8 W=1.0 L=0.15 nf=1 m=1
XSN18 TN DB18 N18 VSS sky130_fd_pr__nfet_01v8 W=1.0 L=0.15 nf=1 m=1
XU19 N19 G VSS VSS sky130_fd_pr__nfet_01v8 W=0.5 L=1.0 nf=1 m=1
XSP19 TP D19 N19 VSS sky130_fd_pr__nfet_01v8 W=1.0 L=0.15 nf=1 m=1
XSN19 TN DB19 N19 VSS sky130_fd_pr__nfet_01v8 W=1.0 L=0.15 nf=1 m=1
XU20 N20 G VSS VSS sky130_fd_pr__nfet_01v8 W=0.5 L=1.0 nf=1 m=1
XSP20 TP D20 N20 VSS sky130_fd_pr__nfet_01v8 W=1.0 L=0.15 nf=1 m=1
XSN20 TN DB20 N20 VSS sky130_fd_pr__nfet_01v8 W=1.0 L=0.15 nf=1 m=1
XU21 N21 G VSS VSS sky130_fd_pr__nfet_01v8 W=0.5 L=1.0 nf=1 m=1
XSP21 TP D21 N21 VSS sky130_fd_pr__nfet_01v8 W=1.0 L=0.15 nf=1 m=1
XSN21 TN DB21 N21 VSS sky130_fd_pr__nfet_01v8 W=1.0 L=0.15 nf=1 m=1
XU22 N22 G VSS VSS sky130_fd_pr__nfet_01v8 W=0.5 L=1.0 nf=1 m=1
XSP22 TP D22 N22 VSS sky130_fd_pr__nfet_01v8 W=1.0 L=0.15 nf=1 m=1
XSN22 TN DB22 N22 VSS sky130_fd_pr__nfet_01v8 W=1.0 L=0.15 nf=1 m=1
XU23 N23 G VSS VSS sky130_fd_pr__nfet_01v8 W=0.5 L=1.0 nf=1 m=1
XSP23 TP D23 N23 VSS sky130_fd_pr__nfet_01v8 W=1.0 L=0.15 nf=1 m=1
XSN23 TN DB23 N23 VSS sky130_fd_pr__nfet_01v8 W=1.0 L=0.15 nf=1 m=1
XU24 N24 G VSS VSS sky130_fd_pr__nfet_01v8 W=0.5 L=1.0 nf=1 m=1
XSP24 TP D24 N24 VSS sky130_fd_pr__nfet_01v8 W=1.0 L=0.15 nf=1 m=1
XSN24 TN DB24 N24 VSS sky130_fd_pr__nfet_01v8 W=1.0 L=0.15 nf=1 m=1
XU25 N25 G VSS VSS sky130_fd_pr__nfet_01v8 W=0.5 L=1.0 nf=1 m=1
XSP25 TP D25 N25 VSS sky130_fd_pr__nfet_01v8 W=1.0 L=0.15 nf=1 m=1
XSN25 TN DB25 N25 VSS sky130_fd_pr__nfet_01v8 W=1.0 L=0.15 nf=1 m=1
XU26 N26 G VSS VSS sky130_fd_pr__nfet_01v8 W=0.5 L=1.0 nf=1 m=1
XSP26 TP D26 N26 VSS sky130_fd_pr__nfet_01v8 W=1.0 L=0.15 nf=1 m=1
XSN26 TN DB26 N26 VSS sky130_fd_pr__nfet_01v8 W=1.0 L=0.15 nf=1 m=1
XU27 N27 G VSS VSS sky130_fd_pr__nfet_01v8 W=0.5 L=1.0 nf=1 m=1
XSP27 TP D27 N27 VSS sky130_fd_pr__nfet_01v8 W=1.0 L=0.15 nf=1 m=1
XSN27 TN DB27 N27 VSS sky130_fd_pr__nfet_01v8 W=1.0 L=0.15 nf=1 m=1
XU28 N28 G VSS VSS sky130_fd_pr__nfet_01v8 W=0.5 L=1.0 nf=1 m=1
XSP28 TP D28 N28 VSS sky130_fd_pr__nfet_01v8 W=1.0 L=0.15 nf=1 m=1
XSN28 TN DB28 N28 VSS sky130_fd_pr__nfet_01v8 W=1.0 L=0.15 nf=1 m=1
XU29 N29 G VSS VSS sky130_fd_pr__nfet_01v8 W=0.5 L=1.0 nf=1 m=1
XSP29 TP D29 N29 VSS sky130_fd_pr__nfet_01v8 W=1.0 L=0.15 nf=1 m=1
XSN29 TN DB29 N29 VSS sky130_fd_pr__nfet_01v8 W=1.0 L=0.15 nf=1 m=1
XU30 N30 G VSS VSS sky130_fd_pr__nfet_01v8 W=0.5 L=1.0 nf=1 m=1
XSP30 TP D30 N30 VSS sky130_fd_pr__nfet_01v8 W=1.0 L=0.15 nf=1 m=1
XSN30 TN DB30 N30 VSS sky130_fd_pr__nfet_01v8 W=1.0 L=0.15 nf=1 m=1
XQ1 OUTP LO TP VSS sky130_fd_pr__nfet_01v8 W=4.0 L=0.15 nf=1 m=1
XQ2 OUTN LOB TP VSS sky130_fd_pr__nfet_01v8 W=4.0 L=0.15 nf=1 m=1
XQ3 OUTN LO TN VSS sky130_fd_pr__nfet_01v8 W=4.0 L=0.15 nf=1 m=1
XQ4 OUTP LOB TN VSS sky130_fd_pr__nfet_01v8 W=4.0 L=0.15 nf=1 m=1
.ends dac_mixer
