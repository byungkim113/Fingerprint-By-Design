.subckt dac_array D0 D1 D2 D3 D4 D5 D6 D7 D8 D9 D10 D11 D12 D13 D14 D15 D16 D17 D18 D19 D20 D21 D22 D23 D24 D25 D26 D27 D28 D29 D30 G VSS
XR G G VSS VSS sky130_fd_pr__nfet_01v8 W=0.5 L=1.0 nf=1 m=1
XU0 D0 G VSS VSS sky130_fd_pr__nfet_01v8 W=0.5 L=1.0 nf=1 m=1
XU1 D1 G VSS VSS sky130_fd_pr__nfet_01v8 W=0.5 L=1.0 nf=1 m=1
XU2 D2 G VSS VSS sky130_fd_pr__nfet_01v8 W=0.5 L=1.0 nf=1 m=1
XU3 D3 G VSS VSS sky130_fd_pr__nfet_01v8 W=0.5 L=1.0 nf=1 m=1
XU4 D4 G VSS VSS sky130_fd_pr__nfet_01v8 W=0.5 L=1.0 nf=1 m=1
XU5 D5 G VSS VSS sky130_fd_pr__nfet_01v8 W=0.5 L=1.0 nf=1 m=1
XU6 D6 G VSS VSS sky130_fd_pr__nfet_01v8 W=0.5 L=1.0 nf=1 m=1
XU7 D7 G VSS VSS sky130_fd_pr__nfet_01v8 W=0.5 L=1.0 nf=1 m=1
XU8 D8 G VSS VSS sky130_fd_pr__nfet_01v8 W=0.5 L=1.0 nf=1 m=1
XU9 D9 G VSS VSS sky130_fd_pr__nfet_01v8 W=0.5 L=1.0 nf=1 m=1
XU10 D10 G VSS VSS sky130_fd_pr__nfet_01v8 W=0.5 L=1.0 nf=1 m=1
XU11 D11 G VSS VSS sky130_fd_pr__nfet_01v8 W=0.5 L=1.0 nf=1 m=1
XU12 D12 G VSS VSS sky130_fd_pr__nfet_01v8 W=0.5 L=1.0 nf=1 m=1
XU13 D13 G VSS VSS sky130_fd_pr__nfet_01v8 W=0.5 L=1.0 nf=1 m=1
XU14 D14 G VSS VSS sky130_fd_pr__nfet_01v8 W=0.5 L=1.0 nf=1 m=1
XU15 D15 G VSS VSS sky130_fd_pr__nfet_01v8 W=0.5 L=1.0 nf=1 m=1
XU16 D16 G VSS VSS sky130_fd_pr__nfet_01v8 W=0.5 L=1.0 nf=1 m=1
XU17 D17 G VSS VSS sky130_fd_pr__nfet_01v8 W=0.5 L=1.0 nf=1 m=1
XU18 D18 G VSS VSS sky130_fd_pr__nfet_01v8 W=0.5 L=1.0 nf=1 m=1
XU19 D19 G VSS VSS sky130_fd_pr__nfet_01v8 W=0.5 L=1.0 nf=1 m=1
XU20 D20 G VSS VSS sky130_fd_pr__nfet_01v8 W=0.5 L=1.0 nf=1 m=1
XU21 D21 G VSS VSS sky130_fd_pr__nfet_01v8 W=0.5 L=1.0 nf=1 m=1
XU22 D22 G VSS VSS sky130_fd_pr__nfet_01v8 W=0.5 L=1.0 nf=1 m=1
XU23 D23 G VSS VSS sky130_fd_pr__nfet_01v8 W=0.5 L=1.0 nf=1 m=1
XU24 D24 G VSS VSS sky130_fd_pr__nfet_01v8 W=0.5 L=1.0 nf=1 m=1
XU25 D25 G VSS VSS sky130_fd_pr__nfet_01v8 W=0.5 L=1.0 nf=1 m=1
XU26 D26 G VSS VSS sky130_fd_pr__nfet_01v8 W=0.5 L=1.0 nf=1 m=1
XU27 D27 G VSS VSS sky130_fd_pr__nfet_01v8 W=0.5 L=1.0 nf=1 m=1
XU28 D28 G VSS VSS sky130_fd_pr__nfet_01v8 W=0.5 L=1.0 nf=1 m=1
XU29 D29 G VSS VSS sky130_fd_pr__nfet_01v8 W=0.5 L=1.0 nf=1 m=1
XU30 D30 G VSS VSS sky130_fd_pr__nfet_01v8 W=0.5 L=1.0 nf=1 m=1
.ends dac_array
