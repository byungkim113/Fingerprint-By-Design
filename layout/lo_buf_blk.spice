.subckt lo_buf_blk LO_PAD IN VDD VSS BLO
XClo LO_PAD LO_G sky130_fd_pr__cap_mim_m3_1 W=31 L=31 MF=1 m=1
XRlo1 LO_G VDD VSS sky130_fd_pr__res_xhigh_po_1p41 L=35.25 mult=1 m=1
XRlo2 LO_G VSS VSS sky130_fd_pr__res_xhigh_po_1p41 L=35.25 mult=1 m=1
XLOF VDD LO_G IN VSS sky130_fd_pr__nfet_01v8 W=20 L=0.15 nf=2 m=1
XLOB BLO BLO VSS VSS sky130_fd_pr__nfet_01v8 W=1 L=0.5 nf=1 m=1
XLOS IN BLO VSS VSS sky130_fd_pr__nfet_01v8 W=2 L=0.5 nf=1 m=1
.ends lo_buf_blk
