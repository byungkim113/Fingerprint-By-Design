.subckt ldo_blk VIN VOUT VSS
XQ1_0 VSS VSS bg_a sky130_fd_pr__pnp_05v5_W3p40L3p40 m=1
XQ1_1 VSS VSS bg_a sky130_fd_pr__pnp_05v5_W3p40L3p40 m=1
XQ2_0 VSS VSS bg_bq sky130_fd_pr__pnp_05v5_W3p40L3p40 m=1
XQ2_1 VSS VSS bg_bq sky130_fd_pr__pnp_05v5_W3p40L3p40 m=1
XQ2_2 VSS VSS bg_bq sky130_fd_pr__pnp_05v5_W3p40L3p40 m=1
XQ2_3 VSS VSS bg_bq sky130_fd_pr__pnp_05v5_W3p40L3p40 m=1
XQ2_4 VSS VSS bg_bq sky130_fd_pr__pnp_05v5_W3p40L3p40 m=1
XQ2_5 VSS VSS bg_bq sky130_fd_pr__pnp_05v5_W3p40L3p40 m=1
XQ2_6 VSS VSS bg_bq sky130_fd_pr__pnp_05v5_W3p40L3p40 m=1
XQ2_7 VSS VSS bg_bq sky130_fd_pr__pnp_05v5_W3p40L3p40 m=1
XQ2_8 VSS VSS bg_bq sky130_fd_pr__pnp_05v5_W3p40L3p40 m=1
XQ2_9 VSS VSS bg_bq sky130_fd_pr__pnp_05v5_W3p40L3p40 m=1
XQ2_10 VSS VSS bg_bq sky130_fd_pr__pnp_05v5_W3p40L3p40 m=1
XQ2_11 VSS VSS bg_bq sky130_fd_pr__pnp_05v5_W3p40L3p40 m=1
XQ2_12 VSS VSS bg_bq sky130_fd_pr__pnp_05v5_W3p40L3p40 m=1
XQ2_13 VSS VSS bg_bq sky130_fd_pr__pnp_05v5_W3p40L3p40 m=1
XQ2_14 VSS VSS bg_bq sky130_fd_pr__pnp_05v5_W3p40L3p40 m=1
XQ2_15 VSS VSS bg_bq sky130_fd_pr__pnp_05v5_W3p40L3p40 m=1
XQ3_0 VSS VSS bg_q3e sky130_fd_pr__pnp_05v5_W3p40L3p40 m=1
XQ3_1 VSS VSS bg_q3e sky130_fd_pr__pnp_05v5_W3p40L3p40 m=1
XR10 bg_b bg_bq VSS sky130_fd_pr__res_xhigh_po_1p41 L=8 mult=1 m=1
XR20 ldo_vref bg_r2m VSS sky130_fd_pr__res_xhigh_po_1p41 L=39 mult=1 m=1
XR21 bg_r2m bg_q3e VSS sky130_fd_pr__res_xhigh_po_1p41 L=39 mult=1 m=1
XMA bg_a ldo_pb VIN VIN sky130_fd_pr__pfet_g5v0d10v5 W=16 L=32 nf=1 m=1
XMB bg_b ldo_pb VIN VIN sky130_fd_pr__pfet_g5v0d10v5 W=16 L=32 nf=1 m=1
XMO ldo_vref ldo_pb VIN VIN sky130_fd_pr__pfet_g5v0d10v5 W=16 L=32 nf=1 m=1
XMTB bg_tl ldo_pb VIN VIN sky130_fd_pr__pfet_g5v0d10v5 W=16 L=32 nf=1 m=1
XM6 ldo_pb ldo_pb VIN VIN sky130_fd_pr__pfet_g5v0d10v5 W=16 L=32 nf=1 m=1
XM1 bg_oa bg_a bg_tl VIN sky130_fd_pr__pfet_g5v0d10v5 W=8 L=16 nf=1 m=1
XM2 bg_ob bg_b bg_tl VIN sky130_fd_pr__pfet_g5v0d10v5 W=8 L=16 nf=1 m=1
XMS1 bg_st VSS VIN VIN sky130_fd_pr__pfet_g5v0d10v5 W=0.42 L=50 nf=1 m=1
XM3 bg_oa bg_oa VSS VSS sky130_fd_pr__nfet_g5v0d10v5 W=16 L=32 nf=1 m=1
XM4 bg_ob bg_oa VSS VSS sky130_fd_pr__nfet_g5v0d10v5 W=16 L=32 nf=1 m=1
XM5 ldo_pb bg_ob VSS VSS sky130_fd_pr__nfet_g5v0d10v5 W=16 L=32 nf=1 m=1
XMS3 bg_st ldo_vref VSS VSS sky130_fd_pr__nfet_g5v0d10v5 W=4 L=0.5 nf=1 m=1
XMS2 ldo_pb bg_st VSS VSS sky130_fd_pr__nfet_g5v0d10v5 W=0.5 L=4 nf=1 m=1
XCCB ldo_pb bg_ob sky130_fd_pr__cap_mim_m3_1 W=22 L=22 MF=1 m=1
XMTP ldo_tb ldo_pb VIN VIN sky130_fd_pr__pfet_g5v0d10v5 W=4 L=8 nf=1 m=1
XMC ldo_a ldo_a VIN VIN sky130_fd_pr__pfet_g5v0d10v5 W=20 L=2 nf=1 m=1
XMD ldo_g ldo_a VIN VIN sky130_fd_pr__pfet_g5v0d10v5 W=20 L=2 nf=1 m=1
XMP VOUT ldo_g VIN VIN sky130_fd_pr__pfet_g5v0d10v5 W=200 L=0.5 nf=20 m=1
XMTN ldo_tb ldo_tb VSS VSS sky130_fd_pr__nfet_g5v0d10v5 W=4 L=2 nf=1 m=1
XMT ldo_tail ldo_tb VSS VSS sky130_fd_pr__nfet_g5v0d10v5 W=8 L=2 nf=1 m=1
XMAO ldo_a ldo_fb ldo_tail VSS sky130_fd_pr__nfet_g5v0d10v5 W=20 L=2 nf=1 m=1
XMBO ldo_g ldo_vss_ref ldo_tail VSS sky130_fd_pr__nfet_g5v0d10v5 W=20 L=2 nf=1 m=1
XCCL ldo_g VOUT sky130_fd_pr__cap_mim_m3_1 W=22 L=22 MF=1 m=1
XGRP ldo_x VSS VIN VIN sky130_fd_pr__pfet_g5v0d10v5 W=0.42 L=20 nf=1 m=1
XGRN ldo_x ldo_vref VSS VSS sky130_fd_pr__nfet_g5v0d10v5 W=2 L=1 nf=1 m=1
XGIP ldo_y ldo_x VIN VIN sky130_fd_pr__pfet_g5v0d10v5 W=2 L=0.5 nf=1 m=1
XGIN ldo_y ldo_x VSS VSS sky130_fd_pr__nfet_g5v0d10v5 W=1 L=0.5 nf=1 m=1
XGSW ldo_g ldo_y VIN VIN sky130_fd_pr__pfet_g5v0d10v5 W=40 L=0.5 nf=4 m=1
XGCX ldo_x VIN sky130_fd_pr__cap_mim_m3_1 W=10 L=10 MF=1 m=1
XGCY ldo_y VSS sky130_fd_pr__cap_mim_m3_1 W=10 L=10 MF=1 m=1
XRSS0 ldo_vref ldo_ss1 VSS sky130_fd_pr__res_xhigh_po_1p41 L=35.25 mult=1 m=1
XRSS1 ldo_ss1 ldo_ss2 VSS sky130_fd_pr__res_xhigh_po_1p41 L=35.25 mult=1 m=1
XRSS2 ldo_ss2 ldo_ss3 VSS sky130_fd_pr__res_xhigh_po_1p41 L=35.25 mult=1 m=1
XRSS3 ldo_ss3 ldo_ss4 VSS sky130_fd_pr__res_xhigh_po_1p41 L=35.25 mult=1 m=1
XRSS4 ldo_ss4 ldo_ss5 VSS sky130_fd_pr__res_xhigh_po_1p41 L=35.25 mult=1 m=1
XRSS5 ldo_ss5 ldo_ss6 VSS sky130_fd_pr__res_xhigh_po_1p41 L=35.25 mult=1 m=1
XRSS6 ldo_ss6 ldo_ss7 VSS sky130_fd_pr__res_xhigh_po_1p41 L=35.25 mult=1 m=1
XRSS7 ldo_ss7 ldo_ss8 VSS sky130_fd_pr__res_xhigh_po_1p41 L=35.25 mult=1 m=1
XRSS8 ldo_ss8 ldo_ss9 VSS sky130_fd_pr__res_xhigh_po_1p41 L=35.25 mult=1 m=1
XRSS9 ldo_ss9 ldo_vss_ref VSS sky130_fd_pr__res_xhigh_po_1p41 L=35.25 mult=1 m=1
XCSS_0 ldo_vss_ref VSS sky130_fd_pr__cap_mim_m3_1 W=28.6 L=28.6 MF=1 m=1
XCSS_1 ldo_vss_ref VSS sky130_fd_pr__cap_mim_m3_1 W=28.6 L=28.6 MF=1 m=1
XCSS_2 ldo_vss_ref VSS sky130_fd_pr__cap_mim_m3_1 W=28.6 L=28.6 MF=1 m=1
XCSS_3 ldo_vss_ref VSS sky130_fd_pr__cap_mim_m3_1 W=28.6 L=28.6 MF=1 m=1
XCSS_4 ldo_vss_ref VSS sky130_fd_pr__cap_mim_m3_1 W=28.6 L=28.6 MF=1 m=1
XCSS_5 ldo_vss_ref VSS sky130_fd_pr__cap_mim_m3_1 W=28.6 L=28.6 MF=1 m=1
XRD1 VOUT ldo_fb VSS sky130_fd_pr__res_xhigh_po_1p41 L=34.1 mult=1 m=1
XRD2 ldo_fb ldo_r2m VSS sky130_fd_pr__res_xhigh_po_1p41 L=35.25 mult=1 m=1
XRD3 ldo_r2m VSS VSS sky130_fd_pr__res_xhigh_po_1p41 L=35.25 mult=1 m=1
XCD0 VSS VOUT VSS VSS sky130_fd_pr__nfet_01v8 W=20 L=20 nf=1 m=1
XCD1 VSS VOUT VSS VSS sky130_fd_pr__nfet_01v8 W=20 L=20 nf=1 m=1
XCD2 VSS VOUT VSS VSS sky130_fd_pr__nfet_01v8 W=20 L=20 nf=1 m=1
XCD3 VSS VOUT VSS VSS sky130_fd_pr__nfet_01v8 W=20 L=20 nf=1 m=1
XCD4 VSS VOUT VSS VSS sky130_fd_pr__nfet_01v8 W=20 L=20 nf=1 m=1
XCD5 VSS VOUT VSS VSS sky130_fd_pr__nfet_01v8 W=20 L=20 nf=1 m=1
XCD6 VSS VOUT VSS VSS sky130_fd_pr__nfet_01v8 W=20 L=20 nf=1 m=1
XCD7 VSS VOUT VSS VSS sky130_fd_pr__nfet_01v8 W=20 L=20 nf=1 m=1
XCD8 VSS VOUT VSS VSS sky130_fd_pr__nfet_01v8 W=20 L=20 nf=1 m=1
XCD9 VSS VOUT VSS VSS sky130_fd_pr__nfet_01v8 W=20 L=20 nf=1 m=1
XCD10 VSS VOUT VSS VSS sky130_fd_pr__nfet_01v8 W=20 L=20 nf=1 m=1
XCD11 VSS VOUT VSS VSS sky130_fd_pr__nfet_01v8 W=20 L=20 nf=1 m=1
XCD12 VSS VOUT VSS VSS sky130_fd_pr__nfet_01v8 W=20 L=20 nf=1 m=1
XCD13 VSS VOUT VSS VSS sky130_fd_pr__nfet_01v8 W=20 L=20 nf=1 m=1
XCD14 VSS VOUT VSS VSS sky130_fd_pr__nfet_01v8 W=20 L=20 nf=1 m=1
.ends ldo_blk
