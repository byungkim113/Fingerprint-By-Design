.subckt bias_ref VDD VSS BI BQ BPA BLO BOB
XM1 N1 N1 VSS VSS sky130_fd_pr__nfet_01v8 W=2 L=1 nf=1 m=1
XM2 PG N1 NR VSS sky130_fd_pr__nfet_01v8 W=8 L=1 nf=1 m=1
XMS2 ST N1 VSS VSS sky130_fd_pr__nfet_01v8 W=1 L=0.5 nf=1 m=1
XMS3 PG ST VSS VSS sky130_fd_pr__nfet_01v8 W=1 L=0.5 nf=1 m=1
XRs NR VSS VSS sky130_fd_pr__res_generic_nd W=1 L=80
XM3 N1 PG VDD VDD sky130_fd_pr__pfet_01v8 W=2 L=1 nf=1 m=1
XM4 PG PG VDD VDD sky130_fd_pr__pfet_01v8 W=2 L=1 nf=1 m=1
XMS1 ST VSS VDD VDD sky130_fd_pr__pfet_01v8 W=0.42 L=10 nf=1 m=1
XMOI BI PG VDD VDD sky130_fd_pr__pfet_01v8 W=2 L=1 nf=1 m=1
XMOQ BQ PG VDD VDD sky130_fd_pr__pfet_01v8 W=2 L=1 nf=1 m=1
XMOPA BPA PG VDD VDD sky130_fd_pr__pfet_01v8 W=20 L=1 nf=10 m=1
XMOLO BLO PG VDD VDD sky130_fd_pr__pfet_01v8 W=20 L=1 nf=10 m=1
XMOOB BOB PG VDD VDD sky130_fd_pr__pfet_01v8 W=20 L=1 nf=10 m=1
.ends bias_ref
