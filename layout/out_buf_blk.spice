.subckt out_buf_blk VDD TXP TXN VSS BOB PDP PDN
XOFP VDD PDP TXP VSS sky130_fd_pr__nfet_01v8 W=40 L=0.15 nf=4 m=1
XOFN VDD PDN TXN VSS sky130_fd_pr__nfet_01v8 W=40 L=0.15 nf=4 m=1
XOBB BOB BOB VSS VSS sky130_fd_pr__nfet_01v8 W=1 L=0.5 nf=1 m=1
XOSP TXP BOB VSS VSS sky130_fd_pr__nfet_01v8 W=20 L=0.5 nf=2 m=1
XOSN TXN BOB VSS VSS sky130_fd_pr__nfet_01v8 W=20 L=0.5 nf=2 m=1
.ends out_buf_blk
