.include "/Users/byungkim/.volare/sky130A/libs.ref/sky130_fd_sc_hd/spice/sky130_fd_sc_hd.spice"
.subckt dac_mixer D0 DB0 D1 DB1 D2 DB2 D3 DB3 D4 DB4 D5 DB5 D6 DB6 D7 DB7 D8 DB8 D9 DB9 D10 DB10 D11 DB11 D12 DB12 D13 DB13 D14 DB14 D15 DB15 D16 DB16 D17 DB17 D18 DB18 D19 DB19 D20 DB20 D21 DB21 D22 DB22 D23 DB23 D24 DB24 D25 DB25 D26 DB26 D27 DB27 D28 DB28 D29 DB29 D30 DB30 OUTP OUTN LO LOB G VSS
XR G G VSS VSS sky130_fd_pr__nfet_01v8 W=0.5 L=1.0 nf=1 m=1
XU0 N0 G VSS VSS sky130_fd_pr__nfet_01v8 W=0.5 L=1.0 nf=1 m=1
XSP0 TP D0 N0 VSS sky130_fd_pr__nfet_01v8 W=1.0 L=0.15 nf=1 m=1
XSN0 TN DB0 N0 VSS sky130_fd_pr__nfet_01v8 W=1.0 L=0.15 nf=1 m=1
XU1 N1 G VSS VSS sky130_fd_pr__nfet_01v8 W=0.5 L=1.0 nf=1 m=1
XSP1 TP D1 N1 VSS sky130_fd_pr__nfet_01v8 W=1.0 L=0.15 nf=1 m=1
XSN1 TN DB1 N1 VSS sky130_fd_pr__nfet_01v8 W=1.0 L=0.15 nf=1 m=1
XU2 N2 G VSS VSS sky130_fd_pr__nfet_01v8 W=0.5 L=1.0 nf=1 m=1
XSP2 TP D2 N2 VSS sky130_fd_pr__nfet_01v8 W=1.0 L=0.15 nf=1 m=1
XSN2 TN DB2 N2 VSS sky130_fd_pr__nfet_01v8 W=1.0 L=0.15 nf=1 m=1
XU3 N3 G VSS VSS sky130_fd_pr__nfet_01v8 W=0.5 L=1.0 nf=1 m=1
XSP3 TP D3 N3 VSS sky130_fd_pr__nfet_01v8 W=1.0 L=0.15 nf=1 m=1
XSN3 TN DB3 N3 VSS sky130_fd_pr__nfet_01v8 W=1.0 L=0.15 nf=1 m=1
XU4 N4 G VSS VSS sky130_fd_pr__nfet_01v8 W=0.5 L=1.0 nf=1 m=1
XSP4 TP D4 N4 VSS sky130_fd_pr__nfet_01v8 W=1.0 L=0.15 nf=1 m=1
XSN4 TN DB4 N4 VSS sky130_fd_pr__nfet_01v8 W=1.0 L=0.15 nf=1 m=1
XU5 N5 G VSS VSS sky130_fd_pr__nfet_01v8 W=0.5 L=1.0 nf=1 m=1
XSP5 TP D5 N5 VSS sky130_fd_pr__nfet_01v8 W=1.0 L=0.15 nf=1 m=1
XSN5 TN DB5 N5 VSS sky130_fd_pr__nfet_01v8 W=1.0 L=0.15 nf=1 m=1
XU6 N6 G VSS VSS sky130_fd_pr__nfet_01v8 W=0.5 L=1.0 nf=1 m=1
XSP6 TP D6 N6 VSS sky130_fd_pr__nfet_01v8 W=1.0 L=0.15 nf=1 m=1
XSN6 TN DB6 N6 VSS sky130_fd_pr__nfet_01v8 W=1.0 L=0.15 nf=1 m=1
XU7 N7 G VSS VSS sky130_fd_pr__nfet_01v8 W=0.5 L=1.0 nf=1 m=1
XSP7 TP D7 N7 VSS sky130_fd_pr__nfet_01v8 W=1.0 L=0.15 nf=1 m=1
XSN7 TN DB7 N7 VSS sky130_fd_pr__nfet_01v8 W=1.0 L=0.15 nf=1 m=1
XU8 N8 G VSS VSS sky130_fd_pr__nfet_01v8 W=0.5 L=1.0 nf=1 m=1
XSP8 TP D8 N8 VSS sky130_fd_pr__nfet_01v8 W=1.0 L=0.15 nf=1 m=1
XSN8 TN DB8 N8 VSS sky130_fd_pr__nfet_01v8 W=1.0 L=0.15 nf=1 m=1
XU9 N9 G VSS VSS sky130_fd_pr__nfet_01v8 W=0.5 L=1.0 nf=1 m=1
XSP9 TP D9 N9 VSS sky130_fd_pr__nfet_01v8 W=1.0 L=0.15 nf=1 m=1
XSN9 TN DB9 N9 VSS sky130_fd_pr__nfet_01v8 W=1.0 L=0.15 nf=1 m=1
XU10 N10 G VSS VSS sky130_fd_pr__nfet_01v8 W=0.5 L=1.0 nf=1 m=1
XSP10 TP D10 N10 VSS sky130_fd_pr__nfet_01v8 W=1.0 L=0.15 nf=1 m=1
XSN10 TN DB10 N10 VSS sky130_fd_pr__nfet_01v8 W=1.0 L=0.15 nf=1 m=1
XU11 N11 G VSS VSS sky130_fd_pr__nfet_01v8 W=0.5 L=1.0 nf=1 m=1
XSP11 TP D11 N11 VSS sky130_fd_pr__nfet_01v8 W=1.0 L=0.15 nf=1 m=1
XSN11 TN DB11 N11 VSS sky130_fd_pr__nfet_01v8 W=1.0 L=0.15 nf=1 m=1
XU12 N12 G VSS VSS sky130_fd_pr__nfet_01v8 W=0.5 L=1.0 nf=1 m=1
XSP12 TP D12 N12 VSS sky130_fd_pr__nfet_01v8 W=1.0 L=0.15 nf=1 m=1
XSN12 TN DB12 N12 VSS sky130_fd_pr__nfet_01v8 W=1.0 L=0.15 nf=1 m=1
XU13 N13 G VSS VSS sky130_fd_pr__nfet_01v8 W=0.5 L=1.0 nf=1 m=1
XSP13 TP D13 N13 VSS sky130_fd_pr__nfet_01v8 W=1.0 L=0.15 nf=1 m=1
XSN13 TN DB13 N13 VSS sky130_fd_pr__nfet_01v8 W=1.0 L=0.15 nf=1 m=1
XU14 N14 G VSS VSS sky130_fd_pr__nfet_01v8 W=0.5 L=1.0 nf=1 m=1
XSP14 TP D14 N14 VSS sky130_fd_pr__nfet_01v8 W=1.0 L=0.15 nf=1 m=1
XSN14 TN DB14 N14 VSS sky130_fd_pr__nfet_01v8 W=1.0 L=0.15 nf=1 m=1
XU15 N15 G VSS VSS sky130_fd_pr__nfet_01v8 W=0.5 L=1.0 nf=1 m=1
XSP15 TP D15 N15 VSS sky130_fd_pr__nfet_01v8 W=1.0 L=0.15 nf=1 m=1
XSN15 TN DB15 N15 VSS sky130_fd_pr__nfet_01v8 W=1.0 L=0.15 nf=1 m=1
XU16 N16 G VSS VSS sky130_fd_pr__nfet_01v8 W=0.5 L=1.0 nf=1 m=1
XSP16 TP D16 N16 VSS sky130_fd_pr__nfet_01v8 W=1.0 L=0.15 nf=1 m=1
XSN16 TN DB16 N16 VSS sky130_fd_pr__nfet_01v8 W=1.0 L=0.15 nf=1 m=1
XU17 N17 G VSS VSS sky130_fd_pr__nfet_01v8 W=0.5 L=1.0 nf=1 m=1
XSP17 TP D17 N17 VSS sky130_fd_pr__nfet_01v8 W=1.0 L=0.15 nf=1 m=1
XSN17 TN DB17 N17 VSS sky130_fd_pr__nfet_01v8 W=1.0 L=0.15 nf=1 m=1
XU18 N18 G VSS VSS sky130_fd_pr__nfet_01v8 W=0.5 L=1.0 nf=1 m=1
XSP18 TP D18 N18 VSS sky130_fd_pr__nfet_01v8 W=1.0 L=0.15 nf=1 m=1
XSN18 TN DB18 N18 VSS sky130_fd_pr__nfet_01v8 W=1.0 L=0.15 nf=1 m=1
XU19 N19 G VSS VSS sky130_fd_pr__nfet_01v8 W=0.5 L=1.0 nf=1 m=1
XSP19 TP D19 N19 VSS sky130_fd_pr__nfet_01v8 W=1.0 L=0.15 nf=1 m=1
XSN19 TN DB19 N19 VSS sky130_fd_pr__nfet_01v8 W=1.0 L=0.15 nf=1 m=1
XU20 N20 G VSS VSS sky130_fd_pr__nfet_01v8 W=0.5 L=1.0 nf=1 m=1
XSP20 TP D20 N20 VSS sky130_fd_pr__nfet_01v8 W=1.0 L=0.15 nf=1 m=1
XSN20 TN DB20 N20 VSS sky130_fd_pr__nfet_01v8 W=1.0 L=0.15 nf=1 m=1
XU21 N21 G VSS VSS sky130_fd_pr__nfet_01v8 W=0.5 L=1.0 nf=1 m=1
XSP21 TP D21 N21 VSS sky130_fd_pr__nfet_01v8 W=1.0 L=0.15 nf=1 m=1
XSN21 TN DB21 N21 VSS sky130_fd_pr__nfet_01v8 W=1.0 L=0.15 nf=1 m=1
XU22 N22 G VSS VSS sky130_fd_pr__nfet_01v8 W=0.5 L=1.0 nf=1 m=1
XSP22 TP D22 N22 VSS sky130_fd_pr__nfet_01v8 W=1.0 L=0.15 nf=1 m=1
XSN22 TN DB22 N22 VSS sky130_fd_pr__nfet_01v8 W=1.0 L=0.15 nf=1 m=1
XU23 N23 G VSS VSS sky130_fd_pr__nfet_01v8 W=0.5 L=1.0 nf=1 m=1
XSP23 TP D23 N23 VSS sky130_fd_pr__nfet_01v8 W=1.0 L=0.15 nf=1 m=1
XSN23 TN DB23 N23 VSS sky130_fd_pr__nfet_01v8 W=1.0 L=0.15 nf=1 m=1
XU24 N24 G VSS VSS sky130_fd_pr__nfet_01v8 W=0.5 L=1.0 nf=1 m=1
XSP24 TP D24 N24 VSS sky130_fd_pr__nfet_01v8 W=1.0 L=0.15 nf=1 m=1
XSN24 TN DB24 N24 VSS sky130_fd_pr__nfet_01v8 W=1.0 L=0.15 nf=1 m=1
XU25 N25 G VSS VSS sky130_fd_pr__nfet_01v8 W=0.5 L=1.0 nf=1 m=1
XSP25 TP D25 N25 VSS sky130_fd_pr__nfet_01v8 W=1.0 L=0.15 nf=1 m=1
XSN25 TN DB25 N25 VSS sky130_fd_pr__nfet_01v8 W=1.0 L=0.15 nf=1 m=1
XU26 N26 G VSS VSS sky130_fd_pr__nfet_01v8 W=0.5 L=1.0 nf=1 m=1
XSP26 TP D26 N26 VSS sky130_fd_pr__nfet_01v8 W=1.0 L=0.15 nf=1 m=1
XSN26 TN DB26 N26 VSS sky130_fd_pr__nfet_01v8 W=1.0 L=0.15 nf=1 m=1
XU27 N27 G VSS VSS sky130_fd_pr__nfet_01v8 W=0.5 L=1.0 nf=1 m=1
XSP27 TP D27 N27 VSS sky130_fd_pr__nfet_01v8 W=1.0 L=0.15 nf=1 m=1
XSN27 TN DB27 N27 VSS sky130_fd_pr__nfet_01v8 W=1.0 L=0.15 nf=1 m=1
XU28 N28 G VSS VSS sky130_fd_pr__nfet_01v8 W=0.5 L=1.0 nf=1 m=1
XSP28 TP D28 N28 VSS sky130_fd_pr__nfet_01v8 W=1.0 L=0.15 nf=1 m=1
XSN28 TN DB28 N28 VSS sky130_fd_pr__nfet_01v8 W=1.0 L=0.15 nf=1 m=1
XU29 N29 G VSS VSS sky130_fd_pr__nfet_01v8 W=0.5 L=1.0 nf=1 m=1
XSP29 TP D29 N29 VSS sky130_fd_pr__nfet_01v8 W=1.0 L=0.15 nf=1 m=1
XSN29 TN DB29 N29 VSS sky130_fd_pr__nfet_01v8 W=1.0 L=0.15 nf=1 m=1
XU30 N30 G VSS VSS sky130_fd_pr__nfet_01v8 W=0.5 L=1.0 nf=1 m=1
XSP30 TP D30 N30 VSS sky130_fd_pr__nfet_01v8 W=1.0 L=0.15 nf=1 m=1
XSN30 TN DB30 N30 VSS sky130_fd_pr__nfet_01v8 W=1.0 L=0.15 nf=1 m=1
XQ1 OUTP LO TP VSS sky130_fd_pr__nfet_01v8 W=4.0 L=0.15 nf=1 m=1
XQ2 OUTN LOB TP VSS sky130_fd_pr__nfet_01v8 W=4.0 L=0.15 nf=1 m=1
XQ3 OUTN LO TN VSS sky130_fd_pr__nfet_01v8 W=4.0 L=0.15 nf=1 m=1
XQ4 OUTP LOB TN VSS sky130_fd_pr__nfet_01v8 W=4.0 L=0.15 nf=1 m=1
.ends dac_mixer

.subckt lo_limiter_sub VIN LO LOB VPWR VGND
XCc VIN G sky130_fd_pr__cap_mim_m3_1 W=3 L=3 MF=1 m=1
XRfb1 G S1 VGND sky130_fd_pr__res_xhigh_po_1p41 L=35.25 mult=1 m=1
XRfb2 S1 S2 VGND sky130_fd_pr__res_xhigh_po_1p41 L=35.25 mult=1 m=1
XRfb3 S2 S3 VGND sky130_fd_pr__res_xhigh_po_1p41 L=35.25 mult=1 m=1
XRfb4 S3 A1 VGND sky130_fd_pr__res_xhigh_po_1p41 L=35.25 mult=1 m=1
XL1 G VGND VGND VPWR VPWR A1 sky130_fd_sc_hd__inv_2
XL2 A1 VGND VGND VPWR VPWR A2 sky130_fd_sc_hd__inv_4
XL3 A2 VGND VGND VPWR VPWR LOB sky130_fd_sc_hd__inv_8
XL4 LOB VGND VGND VPWR VPWR LO sky130_fd_sc_hd__inv_8
.ends lo_limiter_sub

.subckt lo_path IN LO_I LOB_I LO_Q LOB_Q VDD VSS
XRi IN VI VSS sky130_fd_pr__res_high_po_1p41 L=25.6 mult=1 m=1
XCi VI VSS sky130_fd_pr__cap_mim_m3_1 W=7.8 L=7.8 MF=1 m=1
XCq VQ IN sky130_fd_pr__cap_mim_m3_1 W=7.8 L=7.8 MF=1 m=1
XRq VQ VSS VSS sky130_fd_pr__res_high_po_1p41 L=20.3 mult=1 m=1
XLI VI LO_I LOB_I VDD VSS lo_limiter_sub
XLQ VQ LO_Q LOB_Q VDD VSS lo_limiter_sub
.ends lo_path

.subckt out_net OUTP OUTN RFP RFN IREF_PA VDD VSS
XRLp VDD OUTP VSS sky130_fd_pr__res_high_po_1p41 L=5.6 mult=1 m=1
XRLn VDD OUTN VSS sky130_fd_pr__res_high_po_1p41 L=5.6 mult=1 m=1
XCLp OUTP VSS sky130_fd_pr__cap_mim_m3_1 W=11 L=11 MF=1 m=1
XCLn OUTN VSS sky130_fd_pr__cap_mim_m3_1 W=11 L=11 MF=1 m=1
XCcp OUTP PG sky130_fd_pr__cap_mim_m3_1 W=31 L=31 MF=1 m=1
XCcn OUTN NG sky130_fd_pr__cap_mim_m3_1 W=31 L=31 MF=1 m=1
XRbp PG VB VSS sky130_fd_pr__res_xhigh_po_1p41 L=14.1 mult=1 m=1
XRbn NG VB VSS sky130_fd_pr__res_xhigh_po_1p41 L=14.1 mult=1 m=1
XRv1 VDD VB VSS sky130_fd_pr__res_xhigh_po_1p41 L=35.25 mult=1 m=1
XRv2 VB VSS VSS sky130_fd_pr__res_xhigh_po_1p41 L=35.25 mult=1 m=1
XPA1 RFN PG PTAIL VSS sky130_fd_pr__nfet_01v8 W=10 L=0.15 nf=1 m=1
XPA2 RFP NG PTAIL VSS sky130_fd_pr__nfet_01v8 W=10 L=0.15 nf=1 m=1
XRPAp VDD RFP VSS sky130_fd_pr__res_high_po_5p73 L=4.3 mult=1 m=1
XRPAn VDD RFN VSS sky130_fd_pr__res_high_po_5p73 L=4.3 mult=1 m=1
XPAB IREF_PA IREF_PA VSS VSS sky130_fd_pr__nfet_01v8 W=1 L=0.5 nf=1 m=1
XPAT PTAIL IREF_PA VSS VSS sky130_fd_pr__nfet_01v8 W=10 L=0.5 nf=1 m=1
.ends out_net

.subckt bias_ref VDD VSS BI BQ BPA BLO BOB
XM1 N1 N1 VSS VSS sky130_fd_pr__nfet_01v8 W=2 L=1 nf=1 m=1
XM2 PG N1 NR VSS sky130_fd_pr__nfet_01v8 W=8 L=1 nf=1 m=1
XMS2 ST N1 VSS VSS sky130_fd_pr__nfet_01v8 W=1 L=0.5 nf=1 m=1
XMS3 PG ST VSS VSS sky130_fd_pr__nfet_01v8 W=1 L=0.5 nf=1 m=1
XRs NR VSS VSS sky130_fd_pr__res_generic_nd W=1 L=80
XM3 N1 PG VDD VDD sky130_fd_pr__pfet_01v8 W=2 L=1 nf=1 m=1
XM4 PG PG VDD VDD sky130_fd_pr__pfet_01v8 W=2 L=1 nf=1 m=1
XMS1 ST VSS VDD VDD sky130_fd_pr__pfet_01v8 W=0.42 L=10 nf=1 m=1
XMOI BI PG VDD VDD sky130_fd_pr__pfet_01v8 W=2 L=1 nf=1 m=1
XMOQ BQ PG VDD VDD sky130_fd_pr__pfet_01v8 W=2 L=1 nf=1 m=1
XMOPA BPA PG VDD VDD sky130_fd_pr__pfet_01v8 W=20 L=1 nf=10 m=1
XMOLO BLO PG VDD VDD sky130_fd_pr__pfet_01v8 W=20 L=1 nf=10 m=1
XMOOB BOB PG VDD VDD sky130_fd_pr__pfet_01v8 W=20 L=1 nf=10 m=1
.ends bias_ref

.subckt lo_buf_blk LO_PAD IN VDD VSS BLO
XClo LO_PAD LO_G sky130_fd_pr__cap_mim_m3_1 W=31 L=31 MF=1 m=1
XRlo1 LO_G VDD VSS sky130_fd_pr__res_xhigh_po_1p41 L=35.25 mult=1 m=1
XRlo2 LO_G VSS VSS sky130_fd_pr__res_xhigh_po_1p41 L=35.25 mult=1 m=1
XLOF VDD LO_G IN VSS sky130_fd_pr__nfet_01v8 W=20 L=0.15 nf=2 m=1
XLOB BLO BLO VSS VSS sky130_fd_pr__nfet_01v8 W=1 L=0.5 nf=1 m=1
XLOS IN BLO VSS VSS sky130_fd_pr__nfet_01v8 W=2 L=0.5 nf=1 m=1
.ends lo_buf_blk

.subckt out_buf_blk VDD TXP TXN VSS BOB PDP PDN
XOFP VDD PDP TXP VSS sky130_fd_pr__nfet_01v8 W=40 L=0.15 nf=4 m=1
XOFN VDD PDN TXN VSS sky130_fd_pr__nfet_01v8 W=40 L=0.15 nf=4 m=1
XOBB BOB BOB VSS VSS sky130_fd_pr__nfet_01v8 W=1 L=0.5 nf=1 m=1
XOSP TXP BOB VSS VSS sky130_fd_pr__nfet_01v8 W=20 L=0.5 nf=2 m=1
XOSN TXN BOB VSS VSS sky130_fd_pr__nfet_01v8 W=20 L=0.5 nf=2 m=1
.ends out_buf_blk

.subckt ldo_blk VIN VOUT VSS
XQ1_0 VSS VSS bg_a sky130_fd_pr__pnp_05v5_W3p40L3p40 m=1
XQ1_1 VSS VSS bg_a sky130_fd_pr__pnp_05v5_W3p40L3p40 m=1
XQ2_0 VSS VSS bg_bq sky130_fd_pr__pnp_05v5_W3p40L3p40 m=1
XQ2_1 VSS VSS bg_bq sky130_fd_pr__pnp_05v5_W3p40L3p40 m=1
XQ2_2 VSS VSS bg_bq sky130_fd_pr__pnp_05v5_W3p40L3p40 m=1
XQ2_3 VSS VSS bg_bq sky130_fd_pr__pnp_05v5_W3p40L3p40 m=1
XQ2_4 VSS VSS bg_bq sky130_fd_pr__pnp_05v5_W3p40L3p40 m=1
XQ2_5 VSS VSS bg_bq sky130_fd_pr__pnp_05v5_W3p40L3p40 m=1
XQ2_6 VSS VSS bg_bq sky130_fd_pr__pnp_05v5_W3p40L3p40 m=1
XQ2_7 VSS VSS bg_bq sky130_fd_pr__pnp_05v5_W3p40L3p40 m=1
XQ2_8 VSS VSS bg_bq sky130_fd_pr__pnp_05v5_W3p40L3p40 m=1
XQ2_9 VSS VSS bg_bq sky130_fd_pr__pnp_05v5_W3p40L3p40 m=1
XQ2_10 VSS VSS bg_bq sky130_fd_pr__pnp_05v5_W3p40L3p40 m=1
XQ2_11 VSS VSS bg_bq sky130_fd_pr__pnp_05v5_W3p40L3p40 m=1
XQ2_12 VSS VSS bg_bq sky130_fd_pr__pnp_05v5_W3p40L3p40 m=1
XQ2_13 VSS VSS bg_bq sky130_fd_pr__pnp_05v5_W3p40L3p40 m=1
XQ2_14 VSS VSS bg_bq sky130_fd_pr__pnp_05v5_W3p40L3p40 m=1
XQ2_15 VSS VSS bg_bq sky130_fd_pr__pnp_05v5_W3p40L3p40 m=1
XQ3_0 VSS VSS bg_q3e sky130_fd_pr__pnp_05v5_W3p40L3p40 m=1
XQ3_1 VSS VSS bg_q3e sky130_fd_pr__pnp_05v5_W3p40L3p40 m=1
XR10 bg_b bg_bq VSS sky130_fd_pr__res_xhigh_po_1p41 L=8 mult=1 m=1
XR20 ldo_vref bg_r2m VSS sky130_fd_pr__res_xhigh_po_1p41 L=39 mult=1 m=1
XR21 bg_r2m bg_q3e VSS sky130_fd_pr__res_xhigh_po_1p41 L=39 mult=1 m=1
XMA bg_a ldo_pb VIN VIN sky130_fd_pr__pfet_g5v0d10v5 W=16 L=32 nf=1 m=1
XMB bg_b ldo_pb VIN VIN sky130_fd_pr__pfet_g5v0d10v5 W=16 L=32 nf=1 m=1
XMO ldo_vref ldo_pb VIN VIN sky130_fd_pr__pfet_g5v0d10v5 W=16 L=32 nf=1 m=1
XMTB bg_tl ldo_pb VIN VIN sky130_fd_pr__pfet_g5v0d10v5 W=16 L=32 nf=1 m=1
XM6 ldo_pb ldo_pb VIN VIN sky130_fd_pr__pfet_g5v0d10v5 W=16 L=32 nf=1 m=1
XM1 bg_oa bg_a bg_tl VIN sky130_fd_pr__pfet_g5v0d10v5 W=8 L=16 nf=1 m=1
XM2 bg_ob bg_b bg_tl VIN sky130_fd_pr__pfet_g5v0d10v5 W=8 L=16 nf=1 m=1
XMS1 bg_st VSS VIN VIN sky130_fd_pr__pfet_g5v0d10v5 W=0.42 L=50 nf=1 m=1
XM3 bg_oa bg_oa VSS VSS sky130_fd_pr__nfet_g5v0d10v5 W=16 L=32 nf=1 m=1
XM4 bg_ob bg_oa VSS VSS sky130_fd_pr__nfet_g5v0d10v5 W=16 L=32 nf=1 m=1
XM5 ldo_pb bg_ob VSS VSS sky130_fd_pr__nfet_g5v0d10v5 W=16 L=32 nf=1 m=1
XMS3 bg_st ldo_vref VSS VSS sky130_fd_pr__nfet_g5v0d10v5 W=4 L=0.5 nf=1 m=1
XMS2 ldo_pb bg_st VSS VSS sky130_fd_pr__nfet_g5v0d10v5 W=0.5 L=4 nf=1 m=1
XCCB ldo_pb bg_ob sky130_fd_pr__cap_mim_m3_1 W=22 L=22 MF=1 m=1
XMTP ldo_tb ldo_pb VIN VIN sky130_fd_pr__pfet_g5v0d10v5 W=4 L=8 nf=1 m=1
XMC ldo_a ldo_a VIN VIN sky130_fd_pr__pfet_g5v0d10v5 W=20 L=2 nf=1 m=1
XMD ldo_g ldo_a VIN VIN sky130_fd_pr__pfet_g5v0d10v5 W=20 L=2 nf=1 m=1
XMP VOUT ldo_g VIN VIN sky130_fd_pr__pfet_g5v0d10v5 W=200 L=0.5 nf=20 m=1
XMTN ldo_tb ldo_tb VSS VSS sky130_fd_pr__nfet_g5v0d10v5 W=4 L=2 nf=1 m=1
XMT ldo_tail ldo_tb VSS VSS sky130_fd_pr__nfet_g5v0d10v5 W=8 L=2 nf=1 m=1
XMAO ldo_a ldo_fb ldo_tail VSS sky130_fd_pr__nfet_g5v0d10v5 W=20 L=2 nf=1 m=1
XMBO ldo_g ldo_vss_ref ldo_tail VSS sky130_fd_pr__nfet_g5v0d10v5 W=20 L=2 nf=1 m=1
XCCL ldo_g VOUT sky130_fd_pr__cap_mim_m3_1 W=22 L=22 MF=1 m=1
XGRP ldo_x VSS VIN VIN sky130_fd_pr__pfet_g5v0d10v5 W=0.42 L=20 nf=1 m=1
XGRN ldo_x ldo_vref VSS VSS sky130_fd_pr__nfet_g5v0d10v5 W=2 L=1 nf=1 m=1
XGIP ldo_y ldo_x VIN VIN sky130_fd_pr__pfet_g5v0d10v5 W=2 L=0.5 nf=1 m=1
XGIN ldo_y ldo_x VSS VSS sky130_fd_pr__nfet_g5v0d10v5 W=1 L=0.5 nf=1 m=1
XGSW ldo_g ldo_y VIN VIN sky130_fd_pr__pfet_g5v0d10v5 W=40 L=0.5 nf=4 m=1
XGCX ldo_x VIN sky130_fd_pr__cap_mim_m3_1 W=10 L=10 MF=1 m=1
XGCY ldo_y VSS sky130_fd_pr__cap_mim_m3_1 W=10 L=10 MF=1 m=1
XRSS0 ldo_vref ldo_ss1 VSS sky130_fd_pr__res_xhigh_po_1p41 L=35.25 mult=1 m=1
XRSS1 ldo_ss1 ldo_ss2 VSS sky130_fd_pr__res_xhigh_po_1p41 L=35.25 mult=1 m=1
XRSS2 ldo_ss2 ldo_ss3 VSS sky130_fd_pr__res_xhigh_po_1p41 L=35.25 mult=1 m=1
XRSS3 ldo_ss3 ldo_ss4 VSS sky130_fd_pr__res_xhigh_po_1p41 L=35.25 mult=1 m=1
XRSS4 ldo_ss4 ldo_ss5 VSS sky130_fd_pr__res_xhigh_po_1p41 L=35.25 mult=1 m=1
XRSS5 ldo_ss5 ldo_ss6 VSS sky130_fd_pr__res_xhigh_po_1p41 L=35.25 mult=1 m=1
XRSS6 ldo_ss6 ldo_ss7 VSS sky130_fd_pr__res_xhigh_po_1p41 L=35.25 mult=1 m=1
XRSS7 ldo_ss7 ldo_ss8 VSS sky130_fd_pr__res_xhigh_po_1p41 L=35.25 mult=1 m=1
XRSS8 ldo_ss8 ldo_ss9 VSS sky130_fd_pr__res_xhigh_po_1p41 L=35.25 mult=1 m=1
XRSS9 ldo_ss9 ldo_vss_ref VSS sky130_fd_pr__res_xhigh_po_1p41 L=35.25 mult=1 m=1
XCSS ldo_vss_ref VSS sky130_fd_pr__cap_mim_m3_1 W=70 L=70 MF=1 m=1
XRD1 VOUT ldo_fb VSS sky130_fd_pr__res_xhigh_po_1p41 L=34.1 mult=1 m=1
XRD2 ldo_fb ldo_r2m VSS sky130_fd_pr__res_xhigh_po_1p41 L=35.25 mult=1 m=1
XRD3 ldo_r2m VSS VSS sky130_fd_pr__res_xhigh_po_1p41 L=35.25 mult=1 m=1
XCD0 VSS VOUT VSS VSS sky130_fd_pr__nfet_01v8 W=20 L=20 nf=1 m=1
XCD1 VSS VOUT VSS VSS sky130_fd_pr__nfet_01v8 W=20 L=20 nf=1 m=1
XCD2 VSS VOUT VSS VSS sky130_fd_pr__nfet_01v8 W=20 L=20 nf=1 m=1
XCD3 VSS VOUT VSS VSS sky130_fd_pr__nfet_01v8 W=20 L=20 nf=1 m=1
XCD4 VSS VOUT VSS VSS sky130_fd_pr__nfet_01v8 W=20 L=20 nf=1 m=1
XCD5 VSS VOUT VSS VSS sky130_fd_pr__nfet_01v8 W=20 L=20 nf=1 m=1
XCD6 VSS VOUT VSS VSS sky130_fd_pr__nfet_01v8 W=20 L=20 nf=1 m=1
XCD7 VSS VOUT VSS VSS sky130_fd_pr__nfet_01v8 W=20 L=20 nf=1 m=1
XCD8 VSS VOUT VSS VSS sky130_fd_pr__nfet_01v8 W=20 L=20 nf=1 m=1
XCD9 VSS VOUT VSS VSS sky130_fd_pr__nfet_01v8 W=20 L=20 nf=1 m=1
XCD10 VSS VOUT VSS VSS sky130_fd_pr__nfet_01v8 W=20 L=20 nf=1 m=1
XCD11 VSS VOUT VSS VSS sky130_fd_pr__nfet_01v8 W=20 L=20 nf=1 m=1
XCD12 VSS VOUT VSS VSS sky130_fd_pr__nfet_01v8 W=20 L=20 nf=1 m=1
XCD13 VSS VOUT VSS VSS sky130_fd_pr__nfet_01v8 W=20 L=20 nf=1 m=1
XCD14 VSS VOUT VSS VSS sky130_fd_pr__nfet_01v8 W=20 L=20 nf=1 m=1
.ends ldo_blk

.subckt tx_core LO_PAD TXP TXN VIN VSS DI0 DBI0 DI1 DBI1 DI2 DBI2 DI3 DBI3 DI4 DBI4 DI5 DBI5 DI6 DBI6 DI7 DBI7 DI8 DBI8 DI9 DBI9 DI10 DBI10 DI11 DBI11 DI12 DBI12 DI13 DBI13 DI14 DBI14 DI15 DBI15 DI16 DBI16 DI17 DBI17 DI18 DBI18 DI19 DBI19 DI20 DBI20 DI21 DBI21 DI22 DBI22 DI23 DBI23 DI24 DBI24 DI25 DBI25 DI26 DBI26 DI27 DBI27 DI28 DBI28 DI29 DBI29 DI30 DBI30 DQ0 DBQ0 DQ1 DBQ1 DQ2 DBQ2 DQ3 DBQ3 DQ4 DBQ4 DQ5 DBQ5 DQ6 DBQ6 DQ7 DBQ7 DQ8 DBQ8 DQ9 DBQ9 DQ10 DBQ10 DQ11 DBQ11 DQ12 DBQ12 DQ13 DBQ13 DQ14 DBQ14 DQ15 DBQ15 DQ16 DBQ16 DQ17 DBQ17 DQ18 DBQ18 DQ19 DBQ19 DQ20 DBQ20 DQ21 DBQ21 DQ22 DBQ22 DQ23 DBQ23 DQ24 DBQ24 DQ25 DBQ25 DQ26 DBQ26 DQ27 DBQ27 DQ28 DBQ28 DQ29 DBQ29 DQ30 DBQ30
XLDO VIN VDD VSS ldo_blk
XI DI0 DBI0 DI1 DBI1 DI2 DBI2 DI3 DBI3 DI4 DBI4 DI5 DBI5 DI6 DBI6 DI7 DBI7 DI8 DBI8 DI9 DBI9 DI10 DBI10 DI11 DBI11 DI12 DBI12 DI13 DBI13 DI14 DBI14 DI15 DBI15 DI16 DBI16 DI17 DBI17 DI18 DBI18 DI19 DBI19 DI20 DBI20 DI21 DBI21 DI22 DBI22 DI23 DBI23 DI24 DBI24 DI25 DBI25 DI26 DBI26 DI27 DBI27 DI28 DBI28 DI29 DBI29 DI30 DBI30 OUTP OUTN LO_I LOB_I IREF_I VSS dac_mixer
XQ DQ0 DBQ0 DQ1 DBQ1 DQ2 DBQ2 DQ3 DBQ3 DQ4 DBQ4 DQ5 DBQ5 DQ6 DBQ6 DQ7 DBQ7 DQ8 DBQ8 DQ9 DBQ9 DQ10 DBQ10 DQ11 DBQ11 DQ12 DBQ12 DQ13 DBQ13 DQ14 DBQ14 DQ15 DBQ15 DQ16 DBQ16 DQ17 DBQ17 DQ18 DBQ18 DQ19 DBQ19 DQ20 DBQ20 DQ21 DBQ21 DQ22 DBQ22 DQ23 DBQ23 DQ24 DBQ24 DQ25 DBQ25 DQ26 DBQ26 DQ27 DBQ27 DQ28 DBQ28 DQ29 DBQ29 DQ30 DBQ30 OUTP OUTN LO_Q LOB_Q IREF_Q VSS dac_mixer
XLO IN LO_I LOB_I LO_Q LOB_Q VDD VSS lo_path
XON OUTP OUTN RFP RFN IREF_PA VDD VSS out_net
XB VDD VSS IREF_I IREF_Q IREF_PA BLO BOB bias_ref
XLB LO_PAD IN VDD VSS BLO lo_buf_blk
XOB VDD TXP TXN VSS BOB RFP RFN out_buf_blk
.ends tx_core
